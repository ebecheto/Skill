defun(valueLast (wave) let((y) y=drGetWaveformYVec(wave)
drGetElem(y drVectorLength(y)-1);=>2.785856e-09 ;=> last plot value
))
