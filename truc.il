let((tip f line)
f=infile("~/.last.il.loaded")
gets(line f) tip=line gets(line f)
cond((tip=="list" ret=list(line);<= en fait je cherche la fonction inverse de sprintf(nil "%L" alist) ...
close(f)

gets(line f) close(f)

let((LAST)
libName = "Cells"
str=strcat(libName "_" a2s(4.0))
;return str

LAST=str
f=outfile("~/.last.il.loaded")
fprintf(f "%L\n" type(str)) close(f)
fprintf(f "%L" str) close(f)
)
