defun( backAnnDC (@optional (session asiGetCurrentSession( )))
sevAnnotateResults(hiGetCurrentWindow()->sevSession 'dcNodeVoltages)
printf("edit(%L)" strcat(asiGetNetlistDir(session) "/" asiGetSimInputFileName(session)) )
)
