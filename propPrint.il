;ineed('propPrint t)

defun( propPrint (@optional (insts geGetSelectedSet()))
unless(insts insts=geGetWindowCellView()~>instances)
foreach(mapcar inst insts
params=(cdfGetInstCDF inst)~>parameters
foreach(mapcar prop inst~>prop
parm=car(setof(param params param~>name==prop~>name)) ;parm~>??
list(prop~>object~>cellName parm~>prompt prop~>name prop~>value parm~>callback))
;list(parm~>prompt prop~>name prop~>value parm~>callback))
)

;; inst=css()
;; inst~>prop;=> (db:0x58ba8f33 db:0x58ba8f5c db:0x58ba8f5f db:0x58ba8f5d db:0x58ba8f5b db:0x58ba8f5a db:0x58ba8f59 db:0x58ba8f58 db:0x58ba8f57 db:0x58ba8f54 db:0x58ba8f53 db:0x58ba8f52 db:0x58ba8f51)
;; prop=car(inst~>prop)
;; prop~>??
;; ;=> (db:0x58ba8f33 cellView db:0x58ba8e9a objType "prop" prop nil enum nil name "r" object db:0x58ba791a range nil value "15189.5" valueType "string" assocTextDisplays nil)
;; inst~>prop~>assocTextDisplays

;; inst~>prop~>name
;; ;=> ("r" "shapeType" "calcMethod" "rsh" "rtot" "rstrip" "encnxs" "encnxe" "encnx" "DoNotUse" "w" "l" "lstrip")
;; rtot=dbFindProp(inst "rtot")
;; rtot~>??;=> (db:0x58ba8f5b cellView db:0x58ba8e9a objType "prop" prop nil enum nil name "rtot" object db:0x58ba791a range nil value "iPar(\"r\")/iPar(\"m\")" valueType "string" assocTextDisplays nil)
;; rtot~>object~>??

;; inst=css()
;; cdfgData=(cdfGetInstCDF inst)
;; foreach(mapcar param cdfgData~>parameters list(param~>name param~>value)) ;=> too much, loop on prop first

;; prop=car(inst~>prop);=> db:0x58ba8f33
;; params=(cdfGetInstCDF inst)~>parameters
;; foreach(mapcar prop inst~>prop
;; parm=car(setof(param params param~>name==prop~>name)) ;parm~>??w
;; list(prop~>object~>cellName parm~>prompt prop~>name prop~>value parm~>callback))

;; parm=car(setof(param params param~>name=="rsh")) ;parm~>??w
;; parm~>??

;; params~>??
;; ;=> ((description nil callback nil choices nil data cdf:0x33bc2930 defValue "rpp1" display "t" dontSave nil editable "nil" formField stringStruct@0x5d6af4d0 id db:0x58ba791c name "model" paramType "string" parseAsCEL nil parseAsNumber nil prompt "Model name" units nil storeDefault nil type "instData" use nil value "rpp1") (description nil callback nil choices nil data cdf:0x33bc2930 defValue "40.0" display "t" dontSave nil editable "nil" formField stringStruct@0x5d6af4e8 id db:0x58ba791c name "voltage" paramType "string" parseAsCEL nil parseAsNumber nil prompt "Voltage" units nil storeDefault nil type "instData" use nil value "40.0") (description nil callback "XpcResCB()" choices ("Resistance" "Length" "Strip Length" "Callbacks Off") data cdf:0x33bc2930 defValue "Resistance" display nil dontSave nil editable "t" formField cyclicStruct@0x5d6af500 id db:0x58ba791c name "calcMethod" paramType "cyclic" parseAsCEL nil parseAsNumber nil prompt "Calculation Method" units nil storeDefault nil type "instData" use nil value "Resistance") (description nil callback "XpcResCB()" choices ("Strips" "Serpentine 90" "Serpentine 45") data cdf:0x33bc2930 defValue "Strips" display nil dontSave nil editable "t" formField cyclicStruct@0x5d6af518 id db:0x58ba791c name "shapeType" paramType "cyclic" parseAsCEL nil parseAsNumber nil prompt "Resistor Shape" units nil storeDefault nil type "instData" use nil value "Strips") (description nil callback "XpcResCB()" choices nil data cdf:0x33bc2930 defValue t display nil dontSave nil editable "t" formField booleanButtonStruct@0x5d6af530 id db:0x58ba791c name "modLimits" paramType "boolean" parseAsCEL nil parseAsNumber nil prompt "Model Limits" units nil storeDefault nil type "instData" use nil value nil) (description nil callback nil choices nil data cdf:0x33bc2930 defValue "1.52091K" display "t" dontSave nil editable "nil" formField stringStruct@0x5d6af548 id db:0x58ba791c name "rtot" paramType "string" parseAsCEL t parseAsNumber t prompt "Total Resistance" units "resistance" storeDefault nil type "instData" use nil value "1520.19") (description nil callback "XpcResCB()" choices nil data cdf:0x33bc2930 defValue "1.52091K" display "t" dontSave nil editable "XfabFormGetParValue( 'calcMethod )==\"Resistance\"" formField stringStruct@0x5d6af560 id db:0x58ba791c name "r" paramType "string" parseAsCEL t parseAsNumber t prompt "Device Resistance" units "resistance" storeDefault nil type "instData" use nil value "1520.19") (description nil callback nil choices nil data cdf:0x33bc2930 defValue "iPar(\"r\")" display nil dontSave nil editable "nil" formField stringStruct@0x5d6af578 id db:0x58ba791c name "rstrip" paramType "string" parseAsCEL t parseAsNumber t prompt "Strip Res" units "resistance" storeDefault nil type "instData" use nil value "1520.19") (description nil callback "XpcResCB()" choices nil data cdf:0x33bc2930 defValue "2u" display "t" dontSave nil editable "t" formField stringStruct@0x5d6af590 id db:0x58ba791c name "w" paramType "string" parseAsCEL t parseAsNumber t prompt "Width" units "lengthMetric" storeDefault nil type "instData" use nil value "2u") (description nil callback "XpcResCB()" choices nil data cdf:0x33bc2930 defValue "10u" display "t" dontSave nil editable "or( XfabFormGetParValue( 'calcMethod )==\"Length\" XfabFormGetParValue( 'calcMethod )==\"Callbacks Off\" ) " formField stringStruct@0x5d6af5a8 id db:0x58ba791c name "l" paramType "string" parseAsCEL t parseAsNumber t prompt "Resistor Length" units "lengthMetric" storeDefault nil type "instData" use nil value "9.995u") (description nil callback "XpcResCB()" choices nil data cdf:0x33bc2930 defValue "10u" display nil dontSave nil editable "XfabFormGetParValue( 'calcMethod )==\"Strip Length\" " formField stringStruct@0x5d6af5c0 id db:0x58ba791c name "lstrip" paramType "string" parseAsCEL t parseAsNumber t prompt "Strip Length" units "lengthMetric" storeDefault nil type "instData" use nil value "9.995u") (description nil callback "XpcResCB()" choices nil data cdf:0x33bc2930 defValue 1 display "t" dontSave nil editable "XfabFormIsViewType( \"maskLayout\" ) || and( XfabFormGetParValue( 'calcMethod )!=\"Callbacks Off\"  XfabFormGetParValue( 'shapeType )!=\"Strips\" )" formField intStruct@0x5d6af5d8 id db:0x58ba791c name "strips" paramType "int" parseAsCEL nil parseAsNumber nil prompt "Number of Strips (Serial)" units nil storeDefault nil type "instData" use nil value 1) (description nil callback nil choices nil data cdf:0x33bc2930 defValue 1 display "nil" dontSave nil editable nil formField nil id db:0x58ba791c name "simStrips" paramType "int" parseAsCEL nil parseAsNumber nil prompt "Number of Strips for Sim" units nil storeDefault nil type "instData" use nil value 1) (description nil callback "XpcResCB()" choices nil data cdf:0x33bc2930 defValue "1" display "t" dontSave nil editable "not( XfabFormIsViewType( \"maskLayout\" ))" formField stringStruct@0x5d6af5f0 id db:0x58ba791c name "m" paramType "string" parseAsCEL t parseAsNumber t prompt "Multiplier (Parallel)" units nil storeDefault nil type "instData" use nil value "1") (description nil callback nil choices nil data cdf:0x33bc2930 defValue "280.0" display "t" dontSave nil editable "nil" formField stringStruct@0x5d6af608 id db:0x58ba791c name "rsh" paramType "string" parseAsCEL t parseAsNumber t prompt "Body Sheet Resistance" units "resistance" storeDefault nil type "instData" use nil value "280.0") (description nil callback nil choices nil data cdf:0x33bc2930 defValue "7.5" display "t" dontSave nil editable "nil" formField stringStruct@0x5d6af620 id db:0x58ba791c name "rcont" paramType "string" parseAsCEL t parseAsNumber t prompt "Single Contact Resistance" units "resistance" storeDefault nil type "instData" use nil value "7.5") (description nil callback "XpcResCB()" choices ("Callbacks" "User Defined") data cdf:0x33bc2930 defValue "Callbacks" display "nil" dontSave nil editable nil formField nil id db:0x58ba791c name "contactCalcMethod" paramType "radio" parseAsCEL nil parseAsNumber nil prompt "Calculate Contact Resistance" units nil storeDefault nil type "instData" use nil value "Callbacks") (description nil callback "XpcResCB()" choices nil data cdf:0x33bc2930 defValue "1" display "nil" dontSave nil editable "XfabFormGetParValue( 'contactCalcMethod ) == \"User Defined\" " formField nil id db:0x58ba791c name "leftCnxCnt" paramType "string" parseAsCEL t parseAsNumber t prompt "Number of Contacts" units nil storeDefault nil type "instData" use nil value "4") (description nil callback "XpcResCB()" choices nil data cdf:0x33bc2930 defValue "1" display "nil" dontSave nil editable "XfabFormGetParValue( 'contactCalcMethod ) == \"User Defined\" " formField nil id db:0x58ba791c name "rightCnxCnt" paramType "string" parseAsCEL t parseAsNumber t prompt "Number of Right Contacts" units nil storeDefault nil type "instData" use nil value "1") (description nil callback nil choices nil data cdf:0x33bc2930 defValue "" display "XfabFormIsInToolDisplay('trise)" dontSave nil editable nil formField nil id db:0x58ba791c name "trise" paramType "string" parseAsCEL t parseAsNumber t prompt "Temp rise from ambient" units nil storeDefault nil type "instData" use nil value "") (description nil callback nil choices nil data cdf:0x33bc2930 defValue nil display "not( XfabFormIsViewType( \"maskLayout\" ))" dontSave nil editable nil formField booleanButtonStruct@0x5d6af638 id db:0x58ba791c name "showLayout" paramType "boolean" parseAsCEL nil parseAsNumber nil prompt "Show Layout Parameters" units nil storeDefault nil type "instData" use nil value nil) (description nil callback nil choices ("Layout" "Layout.everything") data cdf:0x33bc2930 defValue "Layout" display "XfabFormGetParValue( 'showLayout ) || XfabFormIsViewType( \"maskLayout\" )" dontSave nil editable nil formField nil id db:0x58ba791c name "showLayoutType" paramType "cyclic" parseAsCEL nil parseAsNumber nil prompt "Layout Parameter Mode" units nil storeDefault nil type "instData" use nil value "Layout") (description nil callback nil choices ("notValid") data cdf:0x33bc2930 defValue "notValid" display "nil" dontSave nil editable nil formField nil id db:0x58ba791c name "pcLayoutMode" paramType "cyclic" parseAsCEL nil parseAsNumber nil prompt "Layout Variant" units nil storeDefault nil type "instData" use nil value "notValid") (description nil callback nil choices ("Minimum" "Distributed") data cdf:0x33bc2930 defValue "Distributed" display "XpcCdfShowLayout( \"pa\" t )" dontSave nil editable nil formField nil id db:0x58ba791c name "contMethod" paramType "radio" parseAsCEL nil parseAsNumber nil prompt "Contact Placement Method" units nil storeDefault nil type "instData" use nil value "Distributed") (description nil callback nil choices nil data cdf:0x33bc2930 defValue t display "t" dontSave nil editable nil formField booleanButtonStruct@0x5d6af650 id db:0x58ba791c name "contLegacyType" paramType "boolean" parseAsCEL nil parseAsNumber nil prompt "Contacts Legacy Mode" units nil storeDefault nil type "instData" use nil value t) (description nil callback nil choices nil data cdf:0x33bc2930 defValue t display "XpcCdfShowLayout( \"a\" t )" dontSave nil editable nil formField nil id db:0x58ba791c name "connect" paramType "boolean" parseAsCEL nil parseAsNumber nil prompt "Connect Strips" units nil storeDefault nil type "instData" use nil value t) (description nil callback "XpcResCB()" choices ("Inside" "Outside") data cdf:0x33bc2930 defValue "Outside" display "XpcCdfShowLayout( \"pa\" t )" dontSave nil editable nil formField nil id db:0x58ba791c name "cnxLayoutMode" paramType "radio" parseAsCEL nil parseAsNumber nil prompt "Connector Position" units nil storeDefault nil type "instData" use nil value "Outside") (description nil callback "XpcResCB()" choices nil data cdf:0x33bc2930 defValue "260.0n" display "t" dontSave nil editable nil formField stringStruct@0x5d6af668 id db:0x58ba791c name "stripSpace" paramType "string" parseAsCEL t parseAsNumber t prompt "Strip Space" units "lengthMetric" storeDefault nil type "instData" use nil value "260.0n") (description nil callback "XpcResCB()" choices nil data cdf:0x33bc2930 defValue 1 display "XpcCdfShowLayout( \"a\" t )" dontSave nil editable "t" formField nil id db:0x58ba791c name "ctxrows" paramType "int" parseAsCEL nil parseAsNumber nil prompt "Contact Rows" units nil storeDefault nil type "instData" use nil value 1) (description nil callback "XpcCheckCdfIntLimits( 'nTopDummies 0 nil )" choices nil data cdf:0x33bc2930 defValue 0 display "XpcCdfShowLayout( \"a\" t )" dontSave nil editable "t" formField nil id db:0x58ba791c name "nTopDummies" paramType "int" parseAsCEL nil parseAsNumber nil prompt "Top Dummy Segments" units nil storeDefault nil type "instData" use nil value 0) (description nil callback "XpcCheckCdfIntLimits( 'nBottomDummies 0 nil )" choices nil data cdf:0x33bc2930 defValue 0 display "XpcCdfShowLayout( \"a\" t )" dontSave nil editable "t" formField nil id db:0x58ba791c name "nBottomDummies" paramType "int" parseAsCEL nil parseAsNumber nil prompt "Bottom Dummy Segments" units nil storeDefault nil type "instData" use nil value 0) (description nil callback "XpcResCB()" choices nil data cdf:0x33bc2930 defValue "2u" display "XpcCdfShowLayout( \"a\" t )" dontSave nil editable nil formField nil id db:0x58ba791c name "dummyWidth" paramType "string" parseAsCEL t parseAsNumber t prompt "Dummy Width" units "lengthMetric" storeDefault nil type "instData" use nil value "2u") (description nil callback "XpcResCB()" choices nil data cdf:0x33bc2930 defValue "260.0n" display "XpcCdfShowLayout( \"a\" t )" dontSave nil editable nil formField nil id db:0x58ba791c name "dummySpace" paramType "string" parseAsCEL t parseAsNumber t prompt "Dummy Space" units "lengthMetric" storeDefault nil type "instData" use nil value "260.0n") (description nil callback "XpcResCB()" choices nil data cdf:0x33bc2930 defValue "260.0n" display "XpcCdfShowLayout( \"a\" t )" dontSave nil editable nil formField nil id db:0x58ba791c name "dummyStripSpace" paramType "string" parseAsCEL t parseAsNumber t prompt "Dummy To Body Space" units "lengthMetric" storeDefault nil type "instData" use nil value "260.0n") (description nil callback nil choices ("Met1" "Met2" "Met3") data cdf:0x33bc2930 defValue "Met1" display "XpcCdfShowLayout( \"a\" t )" dontSave nil editable nil formField nil id db:0x58ba791c name "leftCnxLayer" paramType "radio" parseAsCEL nil parseAsNumber nil prompt "Left Connection Layer" units nil storeDefault nil type "instData" use nil value "Met1") (description nil callback nil choices ("Direct" "Inside" "Outside") data cdf:0x33bc2930 defValue "Direct" display "nil" dontSave nil editable nil formField nil id db:0x58ba791c name "leftCnxMethod" paramType "radio" parseAsCEL nil parseAsNumber nil prompt "Left Connection Method" units nil storeDefault nil type "instData" use nil value "Direct") (description nil callback nil choices ("Met1" "Met2" "Met3") data cdf:0x33bc2930 defValue "Met1" display "XpcCdfShowLayout( \"a\" t )" dontSave nil editable nil formField nil id db:0x58ba791c name "rightCnxLayer" paramType "radio" parseAsCEL nil parseAsNumber nil prompt "Right Connection Layer" units nil storeDefault nil type "instData" use nil value "Met1") (description nil callback nil choices ("Direct" "Inside" "Outside") data cdf:0x33bc2930 defValue "Direct" display "nil" dontSave nil editable nil formField nil id db:0x58ba791c name "rightCnxMethod" paramType "radio" parseAsCEL nil parseAsNumber nil prompt "Right Connection Method" units nil storeDefault nil type "instData" use nil value "Direct") (description nil callback nil choices nil data cdf:0x33bc2930 defValue t display "XpcCdfShowLayout( \"a\" t )" dontSave nil editable nil formField nil id db:0x58ba791c name "shortDummies" paramType "boolean" parseAsCEL nil parseAsNumber nil prompt "Short Dummies" units nil storeDefault nil type "instData" use nil value t) (description nil callback "XpcResCB()" choices nil data cdf:0x33bc2930 defValue t display "XpcCdfShowLayout( \"b\" t )" dontSave nil editable nil formField nil id db:0x58ba791c name "firstCnts" paramType "boolean" parseAsCEL nil parseAsNumber nil prompt "First Contacts" units nil storeDefault nil type "instData" use nil value t) (description nil callback "XpcResCB()" choices nil data cdf:0x33bc2930 defValue t display "XpcCdfShowLayout( \"b\" t )" dontSave nil editable nil formField nil id db:0x58ba791c name "lastCnts" paramType "boolean" parseAsCEL nil parseAsNumber nil prompt "Last Contacts" units nil storeDefault nil type "instData" use nil value t) (description nil callback nil choices nil data cdf:0x33bc2930 defValue "-1" display "nil" dontSave nil editable "nil" formField nil id db:0x58ba791c name "encnxs" paramType "string" parseAsCEL t parseAsNumber t prompt "Number of Contacts S" units nil storeDefault nil type "instData" use nil value "4") (description nil callback nil choices nil data cdf:0x33bc2930 defValue "-1" display "nil" dontSave nil editable "nil" formField nil id db:0x58ba791c name "encnxe" paramType "string" parseAsCEL t parseAsNumber t prompt "Number of Contacts E" units nil storeDefault nil type "instData" use nil value "4") (description nil callback nil choices nil data cdf:0x33bc2930 defValue "-1" display "nil" dontSave nil editable "nil" formField nil id db:0x58ba791c name "encnx" paramType "string" parseAsCEL t parseAsNumber t prompt "Number of Contacts" units nil storeDefault nil type "instData" use nil value "4") (description nil callback "XpcResCB()" choices nil data cdf:0x33bc2930 defValue 0.54 display "XpcCdfShowLayout( \"b\" t )" dontSave nil editable "not( XfabFormGetParValue( 'firstCnts ) )" formField nil id db:0x58ba791c name "firstStretch" paramType "float" parseAsCEL nil parseAsNumber nil prompt "First Contact Offset" units nil storeDefault nil type "instData" use nil value 0.54) (description nil callback "XpcResCB()" choices nil data cdf:0x33bc2930 defValue 0.54 display "XpcCdfShowLayout( \"b\" t )" dontSave nil editable "not( XfabFormGetParValue( 'lastCnts ) )" formField nil id db:0x58ba791c name "lastStretch" paramType "float" parseAsCEL nil parseAsNumber nil prompt "Last Contact Offset" units nil storeDefault nil type "instData" use nil value 0.54) (description nil callback nil choices ("None" "NWELL") data cdf:0x33bc2930 defValue "None" display "t" dontSave nil editable "t" formField radioStruct@0x5d6af680 id db:0x58ba791c name "groundLayer" paramType "radio" parseAsCEL nil parseAsNumber nil prompt "Ground Shield" units nil storeDefault nil type "instData" use nil value "None") (description nil callback nil choices nil data cdf:0x33bc2930 defValue "(p PLUS MINUS)" display "nil" dontSave nil editable nil formField nil id db:0x58ba791c name "permuteRule" paramType "string" parseAsCEL nil parseAsNumber nil prompt "Permutable Pins" units nil storeDefault nil type "instData" use nil value "(p PLUS MINUS)") (description nil callback nil choices nil data cdf:0x33bc2930 defValue "rpp1" display "nil" dontSave nil editable nil formField nil id db:0x58ba791c name "lxUseCell" paramType "string" parseAsCEL nil parseAsNumber nil prompt "lxUseCell" units nil storeDefault nil type "instData" use nil value "rpp1") (description nil callback nil choices nil data cdf:0x33bc2930 defValue "l" display "nil" dontSave nil editable nil formField nil id db:0x58ba791c name "XpcTriggerParam" paramType "string" parseAsCEL nil parseAsNumber nil prompt "XpcTriggerParam" units nil storeDefault nil type "instData" use nil value "l") (description nil callback "XpcGuardbarCB( 1 )" choices ("Ring, Simple" "Ring, Cont.") data cdf:0x33bc2930 defValue "Ring, Simple" display "XpcCdfShowLayout( \"lpa\" t )" dontSave nil editable "t" formField nil id db:0x58ba791c name "surroundGB" paramType "radio" parseAsCEL nil parseAsNumber nil prompt "Surrounding Structure" units nil storeDefault nil type "instData" use nil value "Ring, Simple") (description nil callback "XpcGuardbarCB( )" choices ("None" "Diffusion" "Metal" "_") data cdf:0x33bc2930 defValue "_" display "XpcCdfShowLayout( \"lpa\" t )" dontSave nil editable "t" formField nil id db:0x58ba791c name "guardbarReset" paramType "radio" parseAsCEL nil parseAsNumber nil prompt "Reset Ring to" units nil storeDefault nil type "instData" use nil value "_") (description nil callback "XpcGuardbarCB( 't )" choices ("None" "Diffusion" "Metal") data cdf:0x33bc2930 defValue "None" display "XpcCdfShowLayout( \"lpa\" t )" dontSave nil editable "t" formField nil id db:0x58ba791c name "leftGBConfig" paramType "radio" parseAsCEL nil parseAsNumber nil prompt "Left Side Ring" units nil storeDefault nil type "instData" use nil value "None") (description nil callback "XpcGuardbarCB( 't )" choices ("Normal" "Flush" "Short" "Short, Cont." "Short, Flush" "Meshed" "Mesh Cont.") data cdf:0x33bc2930 defValue "Normal" display "nil" dontSave nil editable "t" formField nil id db:0x58ba791c name "leftBarConfig" paramType "cyclic" parseAsCEL nil parseAsNumber nil prompt "Left Side Bar Type" units nil storeDefault nil type "instData" use nil value "Normal") (description nil callback "XpcGuardbarCB( 't )" choices ("None" "Diffusion" "Metal") data cdf:0x33bc2930 defValue "None" display "XpcCdfShowLayout( \"lpa\" t )" dontSave nil editable "t" formField nil id db:0x58ba791c name "rightGBConfig" paramType "radio" parseAsCEL nil parseAsNumber nil prompt "Right Side Ring" units nil storeDefault nil type "instData" use nil value "None") (description nil callback "XpcGuardbarCB( 't )" choices ("Normal" "Flush" "Short" "Short, Cont." "Short, Flush" "Meshed" "Mesh Cont.") data cdf:0x33bc2930 defValue "Normal" display "nil" dontSave nil editable "t" formField nil id db:0x58ba791c name "rightBarConfig" paramType "cyclic" parseAsCEL nil parseAsNumber nil prompt "Right Side Bar Type" units nil storeDefault nil type "instData" use nil value "Normal") (description nil callback "XpcGuardbarCB( 't )" choices ("None" "Diffusion" "Metal") data cdf:0x33bc2930 defValue "None" display "XpcCdfShowLayout( \"lpa\" t )" dontSave nil editable "t" formField nil id db:0x58ba791c name "topGBConfig" paramType "radio" parseAsCEL nil parseAsNumber nil prompt "Top Side Ring" units nil storeDefault nil type "instData" use nil value "None") (description nil callback "XpcGuardbarCB( 't )" choices ("Normal" "Flush" "Short" "Short, Cont." "Short, Flush" "Meshed" "Mesh Cont.") data cdf:0x33bc2930 defValue "Normal" display "nil" dontSave nil editable "t" formField nil id db:0x58ba791c name "topBarConfig" paramType "cyclic" parseAsCEL nil parseAsNumber nil prompt "Top Side Bar Type" units nil storeDefault nil type "instData" use nil value "Normal") (description nil callback "XpcGuardbarCB( 't )" choices ("None" "Diffusion" "Metal") data cdf:0x33bc2930 defValue "None" display "XpcCdfShowLayout( \"lpa\" t )" dontSave nil editable "t" formField nil id db:0x58ba791c name "bottomGBConfig" paramType "radio" parseAsCEL nil parseAsNumber nil prompt "Bottom Side Ring" units nil storeDefault nil type "instData" use nil value "None") (description nil callback "XpcGuardbarCB( 't )" choices ("Normal" "Flush" "Short" "Short, Cont." "Short, Flush" "Meshed" "Mesh Cont.") data cdf:0x33bc2930 defValue "Normal" display "nil" dontSave nil editable "t" formField nil id db:0x58ba791c name "bottomBarConfig" paramType "cyclic" parseAsCEL nil parseAsNumber nil prompt "Bottom Side Bar Type" units nil storeDefault nil type "instData" use nil value "Normal") (description nil callback nil choices nil data cdf:0x33bc2930 defValue nil display "nil" dontSave nil editable nil formField nil id db:0x58ba791c name "scndGuardBar" paramType "boolean" parseAsCEL nil parseAsNumber nil prompt "Second Well Guardbar" units nil storeDefault nil type "instData" use nil value nil) (description nil callback nil choices nil data cdf:0x33bc2930 defValue nil display "nil" dontSave nil editable nil formField nil id db:0x58ba791c name "thrdGuardBar" paramType "boolean" parseAsCEL nil parseAsNumber nil prompt "Surrounding Guardbar" units nil storeDefault nil type "instData" use nil value nil) (description nil callback nil choices nil data cdf:0x33bc2930 defValue nil display "nil" dontSave nil editable nil formField nil id db:0x58ba791c name "drawTrench" paramType "boolean" parseAsCEL nil parseAsNumber nil prompt "Draw Trench" units nil storeDefault nil type "instData" use nil value nil) (description nil callback nil choices nil data cdf:0x33bc2930 defValue t display "nil" dontSave nil editable nil formField nil id db:0x58ba791c name "showName" paramType "boolean" parseAsCEL nil parseAsNumber nil prompt "Show Device Name" units nil storeDefault nil type "instData" use nil value t) (description nil callback nil choices nil data cdf:0x33bc2930 defValue "rpp1" display "nil" dontSave nil editable nil formField nil id db:0x58ba791c name "layoutName" paramType "string" parseAsCEL nil parseAsNumber nil prompt "Layout Variation" units nil storeDefault nil type "instData" use nil value "rpp1") (description nil callback nil choices nil data cdf:0x33bc2930 defValue "layout" display "nil" dontSave nil editable nil formField nil id db:0x58ba791c name "lxStopList" paramType "string" parseAsCEL nil parseAsNumber nil prompt "lxStopList" units nil storeDefault nil type "instData" use nil value "layout") (description nil callback nil choices nil data cdf:0x33bc2930 defValue "graphic" display nil dontSave nil editable "nil" formField stringStruct@0x5d6af698 id db:0x58ba791c name "ivCellType" paramType "string" parseAsCEL nil parseAsNumber nil prompt "ivCellType" units nil storeDefault nil type "instData" use nil value "graphic") (description nil callback nil choices nil data cdf:0x33bc2930 defValue " model voltage calcMethod modLimits rtot simStrips m rsh rcont contactCalcMethod leftCnxCnt rightCnxCnt trise showLayout showLayoutType pcLayoutMode contMethod contLegacyType connect cnxLayoutMode stripSpace ctxrows nTopDummies nBottomDummies dummyWidth dummySpace dummyStripSpace leftCnxLayer leftCnxMethod rightCnxLayer rightCnxMethod shortDummies firstCnts lastCnts encnxs encnxe encnx firstStretch lastStretch groundLayer permuteRule lxUseCell XpcTriggerParam surroundGB guardbarReset leftGBConfig leftBarConfig rightGBConfig rightBarConfig topGBConfig topBarConfig bottomGBConfig bottomBarConfig scndGuardBar thrdGuardBar drawTrench showName layoutName lxStopList ivCellType lxParamsToIgnore DoNotUse" display "nil" dontSave nil editable nil formField nil id db:0x58ba791c name "lxParamsToIgnore" paramType "string" parseAsCEL nil parseAsNumber nil prompt "lxParamsToIgnore" units nil storeDefault nil type "instData" use nil value " model voltage calcMethod modLimits rtot simStrips m rsh rcont contactCalcMethod leftCnxCnt rightCnxCnt trise showLayout showLayoutType pcLayoutMode contMethod contLegacyType connect cnxLayoutMode stripSpace ctxrows nTopDummies nBottomDummies dummyWidth dummySpace dummyStripSpace leftCnxLayer leftCnxMethod rightCnxLayer rightCnxMethod shortDummies firstCnts lastCnts encnxs encnxe encnx firstStretch lastStretch groundLayer permuteRule lxUseCell XpcTriggerParam surroundGB guardbarReset leftGBConfig leftBarConfig rightGBConfig rightBarConfig topGBConfig topBarConfig bottomGBConfig bottomBarConfig scndGuardBar thrdGuardBar drawTrench showName layoutName lxStopList ivCellType lxParamsToIgnore DoNotUse") (description nil callback nil choices nil data cdf:0x33bc2930 defValue nil display nil dontSave nil editable nil formField nil id db:0x58ba791c name "DoNotUse" paramType "boolean" parseAsCEL nil parseAsNumber nil prompt "DoNotUse:" units nil storeDefault t type "instData" use "nil" value nil))

;; => (description nil callback "XpcResCB()" choices nil data cdf:0x33bc2908 defValue "32.3133K" display "t" dontSave nil editable "XfabFormGetParValue( 'calcMethod )==\"Resistance\"" formField stringStruct@0x2c745470 id db:0x58ba791a name "r" paramType "string" parseAsCEL t parseAsNumber t prompt "Device Resistance" units "resistance" storeDefault nil type "instData" use nil value "15189.5")

;; parm~>??
;; prop~>object~>cellName
;; => (db:0x58ba791a cellView db:0x58ba8e9a objType "inst" prop (db:0x58ba8f33 db:0x58ba8f5d db:0x58ba8f5b db:0x58ba8f5a db:0x58ba8f59 db:0x58ba8f58 db:0x58ba8f57 db:0x58ba8f54 db:0x58ba8f53 db:0x58ba8f52 db:0x58ba8f51) bBox ((-0.25625 1.2125) (0.85625 1.8)) children nil groupMembers nil isAnyInst t isShape nil matchPoints nil net nil parent nil pin nil purpose "cell" textDisplays nil assocTextDisplays nil markers nil figGroup nil baseName "R1" cellName "rnp1h" instHeader db:0x58ba8e21 instTerms (db:0x58ba6f9b db:0x58ba6f9a) libName "PRIMLIB" master db:0x3e66229a name "R1" numInst 1 viewName "symbol" conns (db:0x58ba6f9b db:0x58ba6f9a) mag 1.0 orient "R180" status nil transform ((0.3125 1.3125) "R180" 1.0) xy (0.3125 1.3125) cluster nil blockages nil physOnly nil source "netlist")
;; => (db:0x58ba8f33 cellView db:0x58ba8e9a objType "prop" prop nil enum nil name "r" object db:0x58ba791a range nil value "15189.5" valueType "string" assocTextDisplays nil)
;; => (description nil callback "XpcResCB()" choices nil data cdf:0x33bc2908 defValue "10u" display nil dontSave nil editable "XfabFormGetParValue( 'calcMethod )==\"Strip Length\" " formField stringStruct@0x2c7454d0 id db:0x58ba791a name "lstrip" paramType "string" parseAsCEL t parseAsNumber t prompt "Strip Length" units "lengthMetric" storeDefault nil type "instData" use nil value "18.1u")
