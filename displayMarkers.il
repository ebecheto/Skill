;; copyleft ebecheto

geHiFindMarker()
_hiFormApplyCB(geFindMarkerForm)
i=0 while(geiFindMarker("next")
  i++
geFindMarkerForm->geFindMarkerZoomButton->value= t
  printf("hiZoomIn(hiGetCurrentWindow() '%L )\n" hiGetViewBBox(hiGetCurrentWindow()) )
  )
printf("%d Markers\n" i)

;  printf("bBox %L\n" hiGetViewBBox(hiGetCurrentWindow()) )

;; hiZoomInAtPoint()

;; hiZoomInAtPoint('(438.885 418.995))
;; hiZoomInAtPoint('(439.175 418.705))
;; hiZoomInAtPoint('(433.995 414.105))
;; hiZoomInAtPoint('(434.285 413.815))

;hiZoomInAtPoint('(436.495 411.355))
;hiZoomInAtPoint('(437.205 410.645))
;; hiZoomInAtPoint('(377.265 352.125))
;; hiZoomInAtPoint('(377.975 351.415))
;; hiZoomInAtPoint('(408.355 383.215))
;; hiZoomInAtPoint('(409.065 382.505))
;hiZoomInAtPoint('(418.005 392.865))
;; hiZoomInAtPoint('(436.495 411.355))
;; hiZoomInAtPoint('(437.205 410.645))
;; hiZoomInAtPoint('(418.715 392.155))
;; hiZoomInAtPoint('(344.905 694.755))
;; hiZoomInAtPoint('(345.055 694.905))

;; hiZoomInAtPoint('(356.605 610.685))
;; hiZoomInAtPoint('(356.755 610.835))
