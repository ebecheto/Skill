wid = geGetWindowCellView()
wid~>??
(db:0x2563d59a cellView db:0x2563d59a objType "cellView" prop (db:0x2563d61a db:0x2563d620 db:0x2563d61b db:0x2563d621 db:0x2563d61f db:0x2563d61e db:0x2563d61d db:0x2563d61c) bBox ((-3.11875 -1.7875) (6.73125 3.5625)) lib dd:0x20f2ea00 libName "EXAMPLES" cellName "comparator" cell dd:0x20f2ec98 cellViewType "schematic" cellType "none" conns (db:0x2563d39a db:0x2563d39b db:0x2563d39c db:0x2563d39d db:0x2563d39e db:0x2563d39f db:0x2563d3a0 db:0x2563d3a1 db:0x2563d3a2 db:0x2563d3a3 db:0x2563d3a4 db:0x2563d3a5 db:0x2563d3a6 db:0x2563d3a7 db:0x2563d3a8 db:0x2563d3a9 db:0x2563d3aa db:0x2563d3ab db:0x2563d3ac db:0x2563d3ad db:0x2563d3ae db:0x2563d3af db:0x2563d3b0 db:0x2563d3b1 db:0x2563d3b2 db:0x2563d3b3 db:0x2563d3b4 db:0x2563d3b5 db:0x2563d3b6 db:0x2563d3b7 db:0x2563d3b8 db:0x2563d3b9 db:0x2563d3ba db:0x2563d3bb db:0x2563d3bc db:0x2563d3bd db:0x2563d3be db:0x2563d3bf db:0x2563d3c0 db:0x2563d3c1 db:0x2563d3c2 db:0x2563d3c3 db:0x2563d3c4) constraintGroups nil DBUPerUU 160.0 fileName "/home/validmgr/ebecheto/Work/IC6/EXAMPLES/comparator/cmos_sch/sch.oa" createTime "Jul 10 11:10:44 2013" fileTimeStamp "Jul 10 11:10:53 2013" groupMembers nil groups nil instHeaders (db:0x2450f01a db:0x2450f01b db:0x2450f01c db:0x2450f01d db:0x2450f01e db:0x2450f01f db:0x2450f020 db:0x2450f021 db:0x2450f022) instHeaderRefs nil instRefs nil instanceMasters (db:0x2450829a db:0x2450ef9a db:0x2563b81a db:0x25638a1a db:0x2563cf9a db:0x2563d21a db:0x2450c01a db:0x1e59089a db:0x1e590c1a) instances (db:0x2563e69a db:0x2563e69b db:0x2563e69c db:0x2563e69f db:0x2563e69e db:0x2563e69d db:0x2563e6a1 db:0x2563e6a0 db:0x2563e6a2 db:0x2563e6a3 db:0x2563e6a4 db:0x2563e6a9 db:0x2563e6a8 db:0x2563e6a7 db:0x2563e6a6 db:0x2563e6a5) isParamCell nil layerHeaders (db:0x25636a9a db:0x25636a9b db:0x25636a9c db:0x25636a9d db:0x25636a9e) layerPurposePairs (db:0x2563d49a db:0x2563d49b db:0x2563d49c db:0x2563d49d db:0x2563d49e db:0x2563d49f db:0x2563d4a0 db:0x2563d4a1 db:0x2563d4a2 db:0x2563d4a3 db:0x2563d4a4 db:0x2563d4a5 db:0x2563d4a6) lpps (db:0x2563d49a db:0x2563d49b db:0x2563d49c db:0x2563d49d db:0x2563d49e db:0x2563d49f db:0x2563d4a0 db:0x2563d4a1 db:0x2563d4a2 db:0x2563d4a3 db:0x2563d4a4 db:0x2563d4a5 db:0x2563d4a6) memInsts ((db:0x2563e69a 0) (db:0x2563e69b 0) (db:0x2563e69c 0) (db:0x2563e69f 0) (db:0x2563e69e 0) (db:0x2563e69d 0) (db:0x2563e6a1 0) (db:0x2563e6a0 0) (db:0x2563e6a2 0) (db:0x2563e6a3 0) (db:0x2563e6a4 0) (db:0x2563e6a9 0) (db:0x2563e6a8 0) (db:0x2563e6a7 0) (db:0x2563e6a6 0) (db:0x2563e6a5 0)) mode "a" modifiedButNotSaved nil modifiedCounter 422 mosaics nil markers nil trackPatterns nil rowHeaders nil rows nil nets (db:0x25636c1a db:0x25636c1b db:0x25636c1c db:0x25636c1d db:0x25636c1e db:0x25636c1f db:0x25636c20 db:0x25636c21 db:0x25636c22 db:0x25636c23 db:0x25636c24 db:0x25636c25 db:0x25636c26 db:0x25636c27 db:0x25636c28) shapes (db:0x2563d41a db:0x2563d41b db:0x2563d41c db:0x2563d41d db:0x2563d41e db:0x2563d41f db:0x2563d420 db:0x2563d421 db:0x2563d422 db:0x2563d423 db:0x2563d424 db:0x2563d425 db:0x2563d426 db:0x2563d427 db:0x2563d428 db:0x2563d429 db:0x2563d42a db:0x2563d42b db:0x2563d42c db:0x2563d42d db:0x2563d42e db:0x2563d42f db:0x2563d430 db:0x2563d431 db:0x2563d432 db:0x2563d433 db:0x2563d434 db:0x2563d435 db:0x2563d436 db:0x2563d437 db:0x2563d438 db:0x2563d439 db:0x2563d43a db:0x2563d43b db:0x2563d43c db:0x2563d43d db:0x2563d43e db:0x2563d43f db:0x2563d440 db:0x2563d441 db:0x2563d442 db:0x2563d443 db:0x2563d444 db:0x2563d445 db:0x2563d446 db:0x2563d447 db:0x2563d448 db:0x2563d449 db:0x2563d44a db:0x2563d44b db:0x2563d44c db:0x2563d44d db:0x2563d44e db:0x2563d44f db:0x2563d450 db:0x2563d451 db:0x2563d452 db:0x2563d453 db:0x2563d454 db:0x2563d455 db:0x2563d456 db:0x2563d457 db:0x2563d458 db:0x2563d459 db:0x2563d45a db:0x2563d45b db:0x2563d45c db:0x2563d45d db:0x2563d45e db:0x2563d45f db:0x2563d460 db:0x2563d461 db:0x2563d462 db:0x2563d463 db:0x2563d464 db:0x2563d465 db:0x2563d466 db:0x2563d467 db:0x2563d468 db:0x2563d469 db:0x2563d46a db:0x2563d46b db:0x2563d46c db:0x2563d46d db:0x2563d46e db:0x2563d46f db:0x2563d470 db:0x2563d471) signals (db:0x25636c1a db:0x25636c1b db:0x25636c1c db:0x25636c1d db:0x25636c1e db:0x25636c1f db:0x25636c20 db:0x25636c21 db:0x25636c22 db:0x25636c23 db:0x25636c24 db:0x25636c25 db:0x25636c26 db:0x25636c27 db:0x25636c28) sigNames ("VDAC" "net12" "net40" "net36" "net21" "net6" "net37" "net32" "net1" "Out" "sample" "VIN" "net23" "VDDA" "GNDA") subMasters nil superMaster nil terminals (db:0x2563ce1a db:0x2563ce1b db:0x2563ce1c db:0x2563ce1d db:0x2563ce1e db:0x2563ce1f) userUnits "inch" viewName "cmos_sch" view dd:0x20f2ec50 textDisplays nil assocTextDisplays nil needRefresh nil netCount 15 anyInstCount 16 termCount 6 clusters nil prBoundary nil snapBoundary nil viaHeaders nil viaMasters nil routes nil steiners nil blockages nil vias nil viaVariants nil guides nil sitePattern nil areaBoundaries nil figGroups nil gCellPatterns nil)

wid~>?
(cellView objType prop bBox lib libName cellName cell cellViewType cellType conns constraintGroups DBUPerUU fileName createTime fileTimeStamp groupMembers groups instHeaders instHeaderRefs instRefs instanceMasters instances isParamCell layerHeaders layerPurposePairs lpps memInsts mode modifiedButNotSaved modifiedCounter mosaics markers trackPatterns rowHeaders rows nets shapes signals sigNames subMasters superMaster terminals userUnits viewName view textDisplays assocTextDisplays needRefresh netCount anyInstCount termCount clusters prBoundary snapBoundary viaHeaders viaMasters routes steiners blockages vias viaVariants guides sitePattern areaBoundaries figGroups gCellPatterns)
wid~>cellView~>??
