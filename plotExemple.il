$CDSDIR/tools/plot/samples/cdsplotinit.sample
http://www.edaboard.co.uk/plots-to-file-from-schematic-editor-t3932,start,15.html

hiGetCurrentWindow()~>cellView~>viewName
cvId=hiGetCurrentWindow()~>cellView
;schematic or symbol plot
when(member(cvId~>viewName list("schematic" "symbol"))
i=0;
while( isFile( filename=sprintf(nil "%s-%s-%s_%d.ps" cvId~>libName cvId~>cellName cvId~>viewName i)) i++)

;plot "cellview"
;set plot options
schPlotOptions = '(nil
area "whole"
plot "Viewing Area"
header nil
plotToFile t
plotterType "postscript2"
plotter         "lprdc"
fit   t
display "display"
tmpdir "/tmp"
copy 1
center t
mail nil
orientation "automatic"
)

schPlotOptions->view=eval(cvId~>viewName)
schPlotOptions->cell=eval(cvId~>cellName)
schPlotOptions->library=eval(cvId~>libName)
schPlotOptions->bBox=cvId~>bBox
schPlotOptions->viewlist=eval(cvId~>viewName)
schPlotOptions->outputfile=filename

;plot schematic
schPlot()
;plot layout
lePlot()
) ; when

;set plot options
schPlotOptions = '(nil area "whole" plot "cellview" header nil plotToFile t plotterType "postscript2" papersize "A4" plotter "lprdc" display "display" tmpdir "/usr/tmp" center t orientation "automatic")
schPlotOptions->view=eval(cvId~>viewName)
schPlotOptions->cell=eval(cvId~>cellName)
schPlotOptions->library=eval(cvId~>libName)
schPlotOptions->bBox=cvId~>bBox
schPlotOptions->viewlist=eval(cvId~>viewName)
schPlotOptions->outputfile=filename

;plot schematic
schPlot()
cmd=sprintf(nil "convert -trim -rotate 90 %s %s.png" filename filename filename )
cmd=sprintf(nil "%s; cat %s |sed \"s/1 setlinewidth/5 setlinewidth/\">%s.sed.ps" cmd  filename filename )
cmd=sprintf(nil "%s; convert -trim -rotate 90 %s.sed.ps %s.png" cmd  filename filename )
cmd=sprintf(nil "%s; cat %s.sed.ps |sed \"s/lineBlue *exch def/lineBlue def/;s/lineRed *exch def/lineRed def/;s/lineGreen exch def/lineGreen def/;\"  > %s.sed_bw.ps" cmd  filename filename )
cmd=sprintf(nil "%s; convert -trim -rotate 90 %s.sed_bw.ps %s_bw.png" cmd  filename filename )
(system cmd)

;layout plot
when(cvId~>viewName == "layout" && needsupdate == 1

;set plot options
lePlotOptions = '(nil
area "whole"
plot "cellview"
noteText ""
notes nil
header t
plotToFile t
plotterType "postscript2"
papersize "A"
plotter "Generic 600 dpi Adobe PostScript
Level 2 Plotter"
display "display"
time "now"
tmpdir "/usr/tmp"
copy 1
center t
mailto ""
mail nil
orientation "automatic"
scale 1.0
plotsize (8.0 9.9)
offset (0.0 0.0)
unit "inches"
gridMultiple 5
gridSpacing 1.000000
gridType "None"
stopLevel 64
startLevel 0
arrayDisplay "Full"
instName "instance"
pathCL "yes"
drawAxesOn nil
iconsOn nil
)

lePlotOptions->view=eval(cvId~>viewName)
lePlotOptions->cell=eval(cvId~>cellName)
lePlotOptions->library=eval(cvId~>libName)
lePlotOptions->outputfile=sprintf(nil
"/usr/tmp/%s:%s:%s.ps" cvId~>libName cvId~>cellName cvId~>viewName)

;plot layout
lePlot()
) ; when

; Plot template generated by schSaveCurrentPlotOptions function - Dec 11 13:38:12 2009
;
schPlotOptions = '(nil
    hierarchy       nil
    hierleveldown   0
    multisheet      nil
    view            "schematic"
    cell            "GB_CPTa.sim"
    library         "T2K_V4"
    plot            "cellview"
    bBox            ((-3.31875 -4.48125) (14.925 4.20625))
    fullarea        t
    noteText        ""
    grid            nil
    indexsheet      t
    notes           nil
    header          nil
    cv              db:211951660
    window          window:3
    plotToFile      t
    mailto          "ebecheto"
    display         "display"
    vsheets         1
    hsheets         1
    pagecount       1
    nullpage        nil
    paperdim        (8.016667 10.55)
    papersize       "A4"
    resolution      600
    plottertype     "postscript2"
    plotter         "lprdc"
    fit             t
    outputfile      "toto.ps"
    time            "now"
    tmpdir          "/tmp"
    copy            1
    unit            "inches"
    scale           0.578280
    center          t
    mail            nil
    orientation     "automatic"
    offset          (0.0 1.496429)
    plotsize        (10.55 5.02381)
)

; Plot template generated by Submit Plot command - Dec 11 14:35:22 2009
;
lePlotOptions = '(nil
    fullarea        t
    view            "layout"
    cell            "INV8"
    library         "T2K_2009"
    bBox            ((-1.725 -0.3) (7.2 13.9))
    plot            "Cellview"
    noteText        ""
    indexsheet      t
    notes           nil
    header          nil
    cv              db:262852652
    window          window:17
    mailto          "ebecheto"
    display         "display"
    vsheets         1
    hsheets         1
    pagecount       1
    nullpage        nil
    paperdim        (8.016667 10.55)
    papersize       "A4"
    resolution      600
    plotterType     "postscript2"
    plotter         "lprdc"
    fit             t
    outputfile      "yoyo.ps"
    plotToFile      t
    time            "now"
    tmpdir          "/usr/tmp"
    copy            1
    unit            "inches"
    scale           18871.127102
    center          t
    mail            nil
    orientation     "automatic"
    offset          (0.6928843 0.0)
    plotsize        (6.630898 10.55)
    gridMultiple    5
    gridSpacing     1.000000
    gridType        "None"
    stopLevel       32
    startLevel      0
    arrayDisplay    "Full"
    instName        "instance"
    pathCL          "yes"
    drawAxesOn      t
    iconsOn         nil
)

;; cmd=sprintf(nil "if grep \"%s|\" ~/.cdsplotinit; then echo yes; else cat >> ~/.cdsplotinit << EOF default|default: \\:type=postscript2: \\:resolution#600: \\:maximumPages#30: \\:paperSize=\"A4\" 4810 6330 172 132: EOF; fi" imprimante)

imprimante="lprdc"
cmd=sprintf(nil "if grep \"%s|\" ~/.cdsplotinit; then echo yes; else echo \"default|default: :type=postscript2: :resolution#600: :maximumPages#30: :paperSize=\\\"A4\\\" 4810 6330 172 132 \" >> ~/.cdsplotinit; fi" imprimante)
(system cmd)
cvId=geGetWindowCellView()
;schematic or symbol plot
if( member(cvId~>viewName list("schematic" "symbol")) then pt="sch" else pt="le" ) i=0;
while( isFile( filename=sprintf(nil "%s-%s-%s_%d.ps" cvId~>libName cvId~>cellName cvId~>viewName i)) i++)

set( concat(pt "PlotOptions") '(nil area "whole" plot "cellview" header nil plotToFile t plotterType "postscript2" papersize "A4" plotter "lprdc" display "display" tmpdir "/usr/tmp" center t orientation "automatic"))

eval(concat(pt "PlotOptions"))->view=eval(cvId~>viewName)
eval(concat(pt "PlotOptions"))->cell=eval(cvId~>cellName)
eval(concat(pt "PlotOptions"))->library=eval(cvId~>libName)
eval(concat(pt "PlotOptions"))->bBox=cvId~>bBox
eval(concat(pt "PlotOptions"))->viewlist=eval(cvId~>viewName)
eval(concat(pt "PlotOptions"))->outputfile=filename
;eval(concat(pt "PlotOptions"))->plotter="lprdc"

;plot schematic
;; schPlot() || lePlot()
; eval(concat(pt "Plot()"));<== ... does not work
evalstring(strcat(pt "Plot()"));<== yeah Works

cmd=sprintf(nil "convert -trim -rotate 90 %s %s.png" filename filename filename )
cmd=sprintf(nil "%s; cat %s |sed \"s/1 setlinewidth/5 setlinewidth/\">%s.sed.ps" cmd  filename filename )
cmd=sprintf(nil "%s; convert -trim -rotate 90 %s.sed.ps %s.png" cmd  filename filename )
cmd=sprintf(nil "%s; cat %s.sed.ps |sed \"s/lineBlue *exch def/lineBlue def/;s/lineRed *exch def/lineRed def/;s/lineGreen exch def/lineGreen def/;\"  > %s.sed_bw.ps" cmd  filename filename )
cmd=sprintf(nil "%s; convert -trim -rotate 90 %s.sed_bw.ps %s_bw.png" cmd  filename filename )
(system cmd)

echo=sprintf(nil "%s" cmd )
(system eko)
