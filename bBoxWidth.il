;; copyleft ebecheto

defun(bBoxWidth (bBox)
caadr(bBox)-caar(bBox)
)

; (setq bBox css()~>bBox)
; bBoxWidth(css()~>bBox)
;
