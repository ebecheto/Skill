;; load("~/AMS_C35/T2K/cpoly.PRIMLIB_SKILL.il")

pcDefinePCell(list(ddGetObj("Ed") "cpoly.PRIMLIB_SKILL" "layout")
    ((BottomCont boolean "TRUE")
	(GRcontactM1 boolean "TRUE")
	(LeftCont boolean "TRUE")
	(RightCont boolean "TRUE")
	(TopCont boolean "TRUE")
	(CenterCont boolean "TRUE")
	(wB float 0.4)
	(wL float 10.0)
	(wR float 0.4)
	(wT float 0.4)
    )
    let((RightCont LeftCont BottomCont TopCont CenterCont
	    GRcontactM1 wR wR0 wR0offset wL
	    wL1 wL1offset wT wT2 wT2offset
	    wB wB3 wB3offset pcMember pcStretchGroup
	    stretchOffsetX stretchOffsetY pcLib pcMaster pcInst
	    pcTerm pcPin pcPinName pcNet pcTermNet
	    pcNetName pcTermNetName pcMosaicInst pcParameters pcParamProp
	    pcStep pcStepX pcStepY pcRepeat pcRepeatX
	    pcRepeatY pcIndexX pcIndexY pcLayer pcPurpose
	    pcLabelText pcLabelHeight pcPropText pcParamText pcCoords
	    pcPathWidth pcPolygonMargin
	)
	(pcLib = (pcCellView~>lib))
	(pcParameters = ((pcCellView~>parameters)~>value))
	(pcParamProp = car(exists(prop pcParameters
		    ((prop~>name) == "RightCont")
		)
	    ))
	(RightCont = (pcParamProp~>value))
	if(((pcParamProp~>valueType) == "boolean")
	    (RightCont = (RightCont == "TRUE"))
	)
	(pcParamProp = car(exists(prop pcParameters
		    ((prop~>name) == "LeftCont")
		)
	    ))
	(LeftCont = (pcParamProp~>value))
	if(((pcParamProp~>valueType) == "boolean")
	    (LeftCont = (LeftCont == "TRUE"))
	)
	(pcParamProp = car(exists(prop pcParameters
		    ((prop~>name) == "BottomCont")
		)
	    ))
	(BottomCont = (pcParamProp~>value))
	if(((pcParamProp~>valueType) == "boolean")
	    (BottomCont = (BottomCont == "TRUE"))
	)
	(pcParamProp = car(exists(prop pcParameters
		    ((prop~>name) == "TopCont")
		)
	    ))
	(TopCont = (pcParamProp~>value))
	if(((pcParamProp~>valueType) == "boolean")
	    (TopCont = (TopCont == "TRUE"))
	)
	(pcParamProp = car(exists(prop pcParameters
		    ((prop~>name) == "CenterCont")
		)
	    ))
	(CenterCont = (pcParamProp~>value))
	if(((pcParamProp~>valueType) == "boolean")
	    (CenterCont = (CenterCont == "TRUE"))
	)
	(pcParamProp = car(exists(prop pcParameters
		    ((prop~>name) == "GRcontactM1")
		)
	    ))
	(GRcontactM1 = (pcParamProp~>value))
	if(((pcParamProp~>valueType) == "boolean")
	    (GRcontactM1 = (GRcontactM1 == "TRUE"))
	)
	(pcParamProp = car(exists(prop pcParameters
		    ((prop~>name) == "wR")
		)
	    ))
	(wR = (pcParamProp~>value))
	if(((pcParamProp~>valueType) == "boolean")
	    (wR = (wR == "TRUE"))
	)
	(pcParamProp = car(exists(prop pcParameters
		    ((prop~>name) == "wL")
		)
	    ))
	(wL = (pcParamProp~>value))
	if(((pcParamProp~>valueType) == "boolean")
	    (wL = (wL == "TRUE"))
	)
	(pcParamProp = car(exists(prop pcParameters
		    ((prop~>name) == "wT")
		)
	    ))
	(wT = (pcParamProp~>value))
	if(((pcParamProp~>valueType) == "boolean")
	    (wT = (wT == "TRUE"))
	)
	(pcParamProp = car(exists(prop pcParameters
		    ((prop~>name) == "wB")
		)
	    ))
	(wB = (pcParamProp~>value))
	if(((pcParamProp~>valueType) == "boolean")
	    (wB = (wB == "TRUE"))
	)
	(wR0 = wR)
	(wL1 = wL)
	(wT2 = wT)
	(wB3 = wB)
	(wR0offset = (wR0 - 0.4))
	(wL1offset = (wL1 - 10))
	(wT2offset = (wT2 - 0.4))
	(wB3offset = (wB3 - 0.4))
	dbReplaceProp(pcCellView "_cmxVersion" "int" 500)
	dbReplaceProp(pcCellView "viewSubType" "string" "maskLayoutParamCell")
	dbReplaceProp(pcCellView "function" "string" "transistor")
	dbReplaceProp(pcCellView "pin#" "int" 12)
	(pcNetName = "MINUS")
	(pcTermNet = dbMakeNet(pcCellView pcNetName nil))
	if(!(pcTerm = dbFindTermByName(pcCellView pcNetName)) then
	    (pcTerm = dbCreateTerm(pcTermNet pcNetName "inputOutput" 0))
	)
	(pcLayer = 35)
	(pcPurpose = "drawing")
	(pcInst = dbCreatePath(pcCellView
		list(pcLayer pcPurpose)
		list(((1.5 - wL1offset):(1.15 - wB3offset))
		    ((1.5 - wL1offset):(13.05 + wT2offset))
		) 0.7 "truncateExtend"
	    ))
	(pcPin = dbCreatePin(pcTermNet pcInst "8"))
	setSGq(pcPin
	    '("top" "bottom" "left" "right") accessDir
	)
	if(!(pcTerm~>pins) then
	    dbDeleteObject(pcTerm)
	    if((!(pcTermNet~>figs) && !(pcTermNet~>instTerms)) then
		dbDeleteObject(pcTermNet)
	    )
	)
	(pcMaster = dbOpenCellViewByType("TECH_C35B4" "P2_C" "symbolic" "maskLayout"))
	if(CenterCont then
	    (pcInst = dbCreateParamInst(pcCellView pcMaster nil
		    (7.45:7.1) "R0"
		    1
		    list(list("column" "int" 2)
			list("row" "int" 2)
		    )
		))
	)
	(pcLayer = 230)
	(pcPurpose = "drawing")
	(pcLabelText = "R")
	(pcLabelHeight = 0.625)
	(pcInst = dbCreateLabel(pcCellView
		list(pcLayer pcPurpose)
		((14.2 + wR0offset):6.775) pcLabelText "centerCenter"
		"R180" "roman" pcLabelHeight
	    ))
	setSGq(pcInst "normalLabel" labelType)
	(pcLayer = 230)
	(pcPurpose = "drawing")
	(pcLabelText = "L")
	(pcLabelHeight = 0.625)
	(pcInst = dbCreateLabel(pcCellView
		list(pcLayer pcPurpose)
		((0.3 - wL1offset):6.775) pcLabelText "centerCenter"
		"R180" "roman" pcLabelHeight
	    ))
	setSGq(pcInst "normalLabel" labelType)
	(pcLayer = 230)
	(pcPurpose = "drawing")
	(pcLabelText = "B")
	(pcLabelHeight = 0.625)
	(pcInst = dbCreateLabel(pcCellView
		list(pcLayer pcPurpose)
		(7.5:(0.35 - wB3offset)) pcLabelText "centerCenter"
		"R0" "roman" pcLabelHeight
	    ))
	setSGq(pcInst "normalLabel" labelType)
	(pcLayer = 230)
	(pcPurpose = "drawing")
	(pcLabelText = "T")
	(pcLabelHeight = 0.625)
	(pcInst = dbCreateLabel(pcCellView
		list(pcLayer pcPurpose)
		(7.5:(13.85 + wT2offset)) pcLabelText "centerCenter"
		"R0" "roman" pcLabelHeight
	    ))
	setSGq(pcInst "normalLabel" labelType)
	(pcLayer = 24)
	(pcPurpose = "drawing")
	(pcInst = dbCreatePath(pcCellView
		list(pcLayer pcPurpose)
		list(((14.8 + wR0offset):(13.85 + wT2offset))
		    ((-0.25 - wL1offset):(13.85 + wT2offset))
		) 1.2 "truncateExtend"
	    ))
	(pcLayer = 24)
	(pcPurpose = "drawing")
	(pcInst = dbCreatePath(pcCellView
		list(pcLayer pcPurpose)
		list(((14.2 + wR0offset):(14.45 + wT2offset))
		    ((14.2 + wR0offset):(-0.25 - wB3offset))
		) 1.2 "truncateExtend"
	    ))
	(pcLayer = 24)
	(pcPurpose = "drawing")
	(pcInst = dbCreatePath(pcCellView
		list(pcLayer pcPurpose)
		list(((-0.25 - wL1offset):(0.35 - wB3offset))
		    ((14.8 + wR0offset):(0.35 - wB3offset))
		) 1.2 "truncateExtend"
	    ))
	(pcLayer = 24)
	(pcPurpose = "drawing")
	(pcInst = dbCreatePath(pcCellView
		list(pcLayer pcPurpose)
		list(((0.35 - wL1offset):(-0.25 - wB3offset))
		    ((0.35 - wL1offset):(14.45 + wT2offset))
		) 1.2 "truncateExtend"
	    ))
	(pcLayer = 10)
	(pcPurpose = "drawing")
	(pcInst = dbCreatePath(pcCellView
		list(pcLayer pcPurpose)
		list(((14.2 + wR0offset):(14.2 + wT2offset))
		    ((14.2 + wR0offset):(0.0 - wB3offset))
		) 0.7 "truncateExtend"
	    ))
	(pcLayer = 10)
	(pcPurpose = "drawing")
	(pcInst = dbCreatePath(pcCellView
		list(pcLayer pcPurpose)
		list(((14.55 + wR0offset):(13.85 + wT2offset))
		    ((0.0 - wL1offset):(13.85 + wT2offset))
		) 0.7 "truncateExtend"
	    ))
	(pcLayer = 10)
	(pcPurpose = "drawing")
	(pcInst = dbCreatePath(pcCellView
		list(pcLayer pcPurpose)
		list(((0.0 - wL1offset):(0.35 - wB3offset))
		    ((14.55 + wR0offset):(0.35 - wB3offset))
		) 0.7 "truncateExtend"
	    ))
	(pcLayer = 10)
	(pcPurpose = "drawing")
	(pcInst = dbCreatePath(pcCellView
		list(pcLayer pcPurpose)
		list(((0.35 - wL1offset):(0.0 - wB3offset))
		    ((0.35 - wL1offset):(14.2 + wT2offset))
		) 0.7 "truncateExtend"
	    ))
	(pcLayer = 35)
	(pcPurpose = "drawing")
	(pcInst = dbCreatePath(pcCellView
		list(pcLayer pcPurpose)
		list(((12.0 + wR0offset):(2.9 - wB3offset))
		    ((2.9 - wL1offset):(2.9 - wB3offset))
		) 0.7 "truncateExtend"
	    ))
	(pcLayer = 35)
	(pcPurpose = "drawing")
	(pcInst = dbCreatePath(pcCellView
		list(pcLayer pcPurpose)
		list(((3.25 - wL1offset):(11.65 + wT2offset))
		    ((3.25 - wL1offset):(2.55 - wB3offset))
		) 0.7 "truncateExtend"
	    ))
	(pcLayer = 35)
	(pcPurpose = "drawing")
	(pcInst = dbCreatePath(pcCellView
		list(pcLayer pcPurpose)
		list(((2.9 - wL1offset):11.3)
		    ((12.0 + wR0offset):11.3)
		) 0.7 "truncateExtend"
	    ))
	(pcLayer = 35)
	(pcPurpose = "drawing")
	(pcInst = dbCreatePath(pcCellView
		list(pcLayer pcPurpose)
		list(((11.65 + wR0offset):(2.55 - wB3offset))
		    ((11.65 + wR0offset):(11.65 + wT2offset))
		) 0.7 "truncateExtend"
	    ))
	(pcLayer = 35)
	(pcPurpose = "drawing")
	(pcInst = dbCreatePath(pcCellView
		list(pcLayer pcPurpose)
		list(((14.55 + wR0offset):(13.85 + wT2offset))
		    ((0.0 - wL1offset):(13.85 + wT2offset))
		) 0.7 "truncateExtend"
	    ))
	(pcLayer = 35)
	(pcPurpose = "drawing")
	(pcInst = dbCreatePath(pcCellView
		list(pcLayer pcPurpose)
		list(((14.2 + wR0offset):(14.2 + wT2offset))
		    ((14.2 + wR0offset):(0.0 - wB3offset))
		) 0.7 "truncateExtend"
	    ))
	(pcLayer = 35)
	(pcPurpose = "drawing")
	(pcInst = dbCreatePath(pcCellView
		list(pcLayer pcPurpose)
		list(((0.0 - wL1offset):(0.35 - wB3offset))
		    ((14.55 + wR0offset):(0.35 - wB3offset))
		) 0.7 "truncateExtend"
	    ))
	(pcLayer = 35)
	(pcPurpose = "drawing")
	(pcInst = dbCreatePath(pcCellView
		list(pcLayer pcPurpose)
		list(((18.9 + wR0offset):11.25)
		    ((18.9 + wR0offset):(1.675 - wB3offset))
		) 0.7 "truncateExtend"
	    ))
	if(GRcontactM1 then
	    (pcLayer = 35)
	    (pcPurpose = "drawing")
	    (pcInst = dbCreateRect(pcCellView
		    list(pcLayer pcPurpose)
		    list(((0.35 - wL1offset):(0.35 - wB3offset))
			((1.85 - wL1offset):(13.85 + wT2offset))
		    )
		))
	)
	(pcLayer = 35)
	(pcPurpose = "drawing")
	(pcInst = dbCreatePath(pcCellView
		list(pcLayer pcPurpose)
		list(((0.35 - wL1offset):(0.0 - wB3offset))
		    ((0.35 - wL1offset):(14.2 + wT2offset))
		) 0.7 "truncateExtend"
	    ))
	(pcLayer = 34)
	(pcPurpose = "drawing")
	(pcInst = dbCreateRect(pcCellView
		list(pcLayer pcPurpose)
		list(((3.05 - wL1offset):(2.7 - wB3offset))
		    (3.45:3.1)
		)
	    ))
	(pcLayer = 34)
	(pcPurpose = "drawing")
	(pcInst = dbCreateRect(pcCellView
		list(pcLayer pcPurpose)
		list((3.875:(2.7 - wB3offset))
		    (4.275:3.1)
		)
	    ))
	(pcLayer = 34)
	(pcPurpose = "drawing")
	(pcInst = dbCreateRect(pcCellView
		list(pcLayer pcPurpose)
		list((4.7:(2.7 - wB3offset))
		    (5.1:3.1)
		)
	    ))
	(pcLayer = 34)
	(pcPurpose = "drawing")
	(pcInst = dbCreateRect(pcCellView
		list(pcLayer pcPurpose)
		list((5.525:(2.7 - wB3offset))
		    (5.925:3.1)
		)
	    ))
	(pcLayer = 34)
	(pcPurpose = "drawing")
	(pcInst = dbCreateRect(pcCellView
		list(pcLayer pcPurpose)
		list((6.35:(2.7 - wB3offset))
		    (6.75:3.1)
		)
	    ))
	(pcLayer = 34)
	(pcPurpose = "drawing")
	(pcInst = dbCreateRect(pcCellView
		list(pcLayer pcPurpose)
		list((7.2:(2.7 - wB3offset))
		    (7.6:3.1)
		)
	    ))
	(pcLayer = 34)
	(pcPurpose = "drawing")
	(pcInst = dbCreateRect(pcCellView
		list(pcLayer pcPurpose)
		list((8.050000000000001:(2.7 - wB3offset))
		    (8.449999999999999:3.1)
		)
	    ))
	(pcLayer = 34)
	(pcPurpose = "drawing")
	(pcInst = dbCreateRect(pcCellView
		list(pcLayer pcPurpose)
		list((8.9:(2.7 - wB3offset))
		    (9.300000000000001:3.1)
		)
	    ))
	(pcLayer = 34)
	(pcPurpose = "drawing")
	(pcInst = dbCreateRect(pcCellView
		list(pcLayer pcPurpose)
		list((9.75:(2.7 - wB3offset))
		    (10.15:3.1)
		)
	    ))
	(pcLayer = 34)
	(pcPurpose = "drawing")
	(pcInst = dbCreateRect(pcCellView
		list(pcLayer pcPurpose)
		list(((10.6 + wR0offset):(2.7 - wB3offset))
		    ((11.0 + wR0offset):3.1)
		)
	    ))
	(pcLayer = 34)
	(pcPurpose = "drawing")
	(pcInst = dbCreateRect(pcCellView
		list(pcLayer pcPurpose)
		list(((11.45 + wR0offset):(2.7 - wB3offset))
		    ((11.85 + wR0offset):3.1)
		)
	    ))
	(pcLayer = 34)
	(pcPurpose = "drawing")
	(pcInst = dbCreateRect(pcCellView
		list(pcLayer pcPurpose)
		list(((3.05 - wL1offset):(2.7 - wB3offset))
		    (3.45:3.1)
		)
	    ))
	(pcLayer = 34)
	(pcPurpose = "drawing")
	(pcInst = dbCreateRect(pcCellView
		list(pcLayer pcPurpose)
		list(((3.05 - wL1offset):3.525)
		    (3.45:3.925)
		)
	    ))
	(pcLayer = 34)
	(pcPurpose = "drawing")
	(pcInst = dbCreateRect(pcCellView
		list(pcLayer pcPurpose)
		list(((3.05 - wL1offset):4.35)
		    (3.45:4.75)
		)
	    ))
	(pcLayer = 34)
	(pcPurpose = "drawing")
	(pcInst = dbCreateRect(pcCellView
		list(pcLayer pcPurpose)
		list(((3.05 - wL1offset):5.175)
		    (3.45:5.575)
		)
	    ))
	(pcLayer = 34)
	(pcPurpose = "drawing")
	(pcInst = dbCreateRect(pcCellView
		list(pcLayer pcPurpose)
		list(((3.05 - wL1offset):6.0)
		    (3.45:6.4)
		)
	    ))
	(pcLayer = 34)
	(pcPurpose = "drawing")
	(pcInst = dbCreateRect(pcCellView
		list(pcLayer pcPurpose)
		list(((3.05 - wL1offset):6.85)
		    (3.45:7.25)
		)
	    ))
	(pcLayer = 34)
	(pcPurpose = "drawing")
	(pcInst = dbCreateRect(pcCellView
		list(pcLayer pcPurpose)
		list(((3.05 - wL1offset):7.7)
		    (3.45:8.1)
		)
	    ))
	(pcLayer = 34)
	(pcPurpose = "drawing")
	(pcInst = dbCreateRect(pcCellView
		list(pcLayer pcPurpose)
		list(((3.05 - wL1offset):8.550000000000001)
		    (3.45:8.949999999999999)
		)
	    ))
	(pcLayer = 34)
	(pcPurpose = "drawing")
	(pcInst = dbCreateRect(pcCellView
		list(pcLayer pcPurpose)
		list(((3.05 - wL1offset):9.4)
		    (3.45:9.800000000000001)
		)
	    ))
	(pcLayer = 34)
	(pcPurpose = "drawing")
	(pcInst = dbCreateRect(pcCellView
		list(pcLayer pcPurpose)
		list(((3.05 - wL1offset):10.25)
		    (3.45:10.65)
		)
	    ))
	(pcLayer = 34)
	(pcPurpose = "drawing")
	(pcInst = dbCreateRect(pcCellView
		list(pcLayer pcPurpose)
		list(((3.05 - wL1offset):11.1)
		    (3.45:(11.5 + wT2offset))
		)
	    ))
	(pcLayer = 34)
	(pcPurpose = "drawing")
	(pcInst = dbCreateRect(pcCellView
		list(pcLayer pcPurpose)
		list(((11.45 + wR0offset):11.1)
		    ((11.85 + wR0offset):(11.5 + wT2offset))
		)
	    ))
	(pcLayer = 34)
	(pcPurpose = "drawing")
	(pcInst = dbCreateRect(pcCellView
		list(pcLayer pcPurpose)
		list(((10.625 + wR0offset):11.1)
		    ((11.025 + wR0offset):(11.5 + wT2offset))
		)
	    ))
	(pcLayer = 34)
	(pcPurpose = "drawing")
	(pcInst = dbCreateRect(pcCellView
		list(pcLayer pcPurpose)
		list((9.800000000000001:11.1)
		    (10.2:(11.5 + wT2offset))
		)
	    ))
	(pcLayer = 34)
	(pcPurpose = "drawing")
	(pcInst = dbCreateRect(pcCellView
		list(pcLayer pcPurpose)
		list((8.975:11.1)
		    (9.375:(11.5 + wT2offset))
		)
	    ))
	(pcLayer = 34)
	(pcPurpose = "drawing")
	(pcInst = dbCreateRect(pcCellView
		list(pcLayer pcPurpose)
		list((8.15:11.1)
		    (8.550000000000001:(11.5 + wT2offset))
		)
	    ))
	(pcLayer = 34)
	(pcPurpose = "drawing")
	(pcInst = dbCreateRect(pcCellView
		list(pcLayer pcPurpose)
		list((7.3:11.1)
		    (7.7:(11.5 + wT2offset))
		)
	    ))
	(pcLayer = 34)
	(pcPurpose = "drawing")
	(pcInst = dbCreateRect(pcCellView
		list(pcLayer pcPurpose)
		list((6.45:11.1)
		    (6.85:(11.5 + wT2offset))
		)
	    ))
	(pcLayer = 34)
	(pcPurpose = "drawing")
	(pcInst = dbCreateRect(pcCellView
		list(pcLayer pcPurpose)
		list((5.6:11.1)
		    (6.0:(11.5 + wT2offset))
		)
	    ))
	(pcLayer = 34)
	(pcPurpose = "drawing")
	(pcInst = dbCreateRect(pcCellView
		list(pcLayer pcPurpose)
		list((4.75:11.1)
		    (5.15:(11.5 + wT2offset))
		)
	    ))
	(pcLayer = 34)
	(pcPurpose = "drawing")
	(pcInst = dbCreateRect(pcCellView
		list(pcLayer pcPurpose)
		list((3.9:11.1)
		    (4.3:(11.5 + wT2offset))
		)
	    ))
	(pcLayer = 34)
	(pcPurpose = "drawing")
	(pcInst = dbCreateRect(pcCellView
		list(pcLayer pcPurpose)
		list(((3.05 - wL1offset):11.1)
		    (3.45:(11.5 + wT2offset))
		)
	    ))
	(pcLayer = 34)
	(pcPurpose = "drawing")
	(pcInst = dbCreateRect(pcCellView
		list(pcLayer pcPurpose)
		list(((11.45 + wR0offset):11.1)
		    ((11.85 + wR0offset):(11.5 + wT2offset))
		)
	    ))
	(pcLayer = 34)
	(pcPurpose = "drawing")
	(pcInst = dbCreateRect(pcCellView
		list(pcLayer pcPurpose)
		list(((11.45 + wR0offset):10.275)
		    ((11.85 + wR0offset):10.675)
		)
	    ))
	(pcLayer = 34)
	(pcPurpose = "drawing")
	(pcInst = dbCreateRect(pcCellView
		list(pcLayer pcPurpose)
		list(((11.45 + wR0offset):9.449999999999999)
		    ((11.85 + wR0offset):9.85)
		)
	    ))
	(pcLayer = 34)
	(pcPurpose = "drawing")
	(pcInst = dbCreateRect(pcCellView
		list(pcLayer pcPurpose)
		list(((11.45 + wR0offset):8.625)
		    ((11.85 + wR0offset):9.025)
		)
	    ))
	(pcLayer = 34)
	(pcPurpose = "drawing")
	(pcInst = dbCreateRect(pcCellView
		list(pcLayer pcPurpose)
		list(((11.45 + wR0offset):7.8)
		    ((11.85 + wR0offset):8.199999999999999)
		)
	    ))
	(pcLayer = 34)
	(pcPurpose = "drawing")
	(pcInst = dbCreateRect(pcCellView
		list(pcLayer pcPurpose)
		list(((11.45 + wR0offset):6.95)
		    ((11.85 + wR0offset):7.35)
		)
	    ))
	(pcLayer = 34)
	(pcPurpose = "drawing")
	(pcInst = dbCreateRect(pcCellView
		list(pcLayer pcPurpose)
		list(((11.45 + wR0offset):6.1)
		    ((11.85 + wR0offset):6.5)
		)
	    ))
	(pcLayer = 34)
	(pcPurpose = "drawing")
	(pcInst = dbCreateRect(pcCellView
		list(pcLayer pcPurpose)
		list(((11.45 + wR0offset):5.25)
		    ((11.85 + wR0offset):5.65)
		)
	    ))
	(pcLayer = 34)
	(pcPurpose = "drawing")
	(pcInst = dbCreateRect(pcCellView
		list(pcLayer pcPurpose)
		list(((11.45 + wR0offset):4.4)
		    ((11.85 + wR0offset):4.8)
		)
	    ))
	(pcLayer = 34)
	(pcPurpose = "drawing")
	(pcInst = dbCreateRect(pcCellView
		list(pcLayer pcPurpose)
		list(((11.45 + wR0offset):3.55)
		    ((11.85 + wR0offset):3.95)
		)
	    ))
	(pcLayer = 34)
	(pcPurpose = "drawing")
	(pcInst = dbCreateRect(pcCellView
		list(pcLayer pcPurpose)
		list(((11.45 + wR0offset):(2.7 - wB3offset))
		    ((11.85 + wR0offset):3.1)
		)
	    ))
	(pcLayer = 34)
	(pcPurpose = "drawing")
	(pcInst = dbCreateRect(pcCellView
		list(pcLayer pcPurpose)
		list(((0.15 - wL1offset):(13.65 + wT2offset))
		    ((0.55 - wL1offset):(14.05 + wT2offset))
		)
	    ))
	(pcLayer = 34)
	(pcPurpose = "drawing")
	(pcInst = dbCreateRect(pcCellView
		list(pcLayer pcPurpose)
		list(((0.95 - wL1offset):(13.65 + wT2offset))
		    ((1.35 - wL1offset):(14.05 + wT2offset))
		)
	    ))
	(pcLayer = 34)
	(pcPurpose = "drawing")
	(pcInst = dbCreateRect(pcCellView
		list(pcLayer pcPurpose)
		list(((1.75 - wL1offset):(13.65 + wT2offset))
		    ((2.15 - wL1offset):(14.05 + wT2offset))
		)
	    ))
	(pcLayer = 34)
	(pcPurpose = "drawing")
	(pcInst = dbCreateRect(pcCellView
		list(pcLayer pcPurpose)
		list(((2.55 - wL1offset):(13.65 + wT2offset))
		    ((2.95 - wL1offset):(14.05 + wT2offset))
		)
	    ))
	(pcLayer = 34)
	(pcPurpose = "drawing")
	(pcInst = dbCreateRect(pcCellView
		list(pcLayer pcPurpose)
		list((3.35:(13.65 + wT2offset))
		    (3.75:(14.05 + wT2offset))
		)
	    ))
	(pcLayer = 34)
	(pcPurpose = "drawing")
	(pcInst = dbCreateRect(pcCellView
		list(pcLayer pcPurpose)
		list((4.15:(13.65 + wT2offset))
		    (4.55:(14.05 + wT2offset))
		)
	    ))
	(pcLayer = 34)
	(pcPurpose = "drawing")
	(pcInst = dbCreateRect(pcCellView
		list(pcLayer pcPurpose)
		list((4.95:(13.65 + wT2offset))
		    (5.35:(14.05 + wT2offset))
		)
	    ))
	(pcLayer = 34)
	(pcPurpose = "drawing")
	(pcInst = dbCreateRect(pcCellView
		list(pcLayer pcPurpose)
		list((5.75:(13.65 + wT2offset))
		    (6.15:(14.05 + wT2offset))
		)
	    ))
	(pcLayer = 34)
	(pcPurpose = "drawing")
	(pcInst = dbCreateRect(pcCellView
		list(pcLayer pcPurpose)
		list((6.575:(13.65 + wT2offset))
		    (6.975:(14.05 + wT2offset))
		)
	    ))
	(pcLayer = 34)
	(pcPurpose = "drawing")
	(pcInst = dbCreateRect(pcCellView
		list(pcLayer pcPurpose)
		list((7.4:(13.65 + wT2offset))
		    (7.8:(14.05 + wT2offset))
		)
	    ))
	(pcLayer = 34)
	(pcPurpose = "drawing")
	(pcInst = dbCreateRect(pcCellView
		list(pcLayer pcPurpose)
		list((8.225:(13.65 + wT2offset))
		    (8.625:(14.05 + wT2offset))
		)
	    ))
	(pcLayer = 34)
	(pcPurpose = "drawing")
	(pcInst = dbCreateRect(pcCellView
		list(pcLayer pcPurpose)
		list((9.050000000000001:(13.65 + wT2offset))
		    (9.449999999999999:(14.05 + wT2offset))
		)
	    ))
	(pcLayer = 34)
	(pcPurpose = "drawing")
	(pcInst = dbCreateRect(pcCellView
		list(pcLayer pcPurpose)
		list((9.875:(13.65 + wT2offset))
		    (10.275:(14.05 + wT2offset))
		)
	    ))
	(pcLayer = 34)
	(pcPurpose = "drawing")
	(pcInst = dbCreateRect(pcCellView
		list(pcLayer pcPurpose)
		list(((10.7 + wR0offset):(13.65 + wT2offset))
		    ((11.1 + wR0offset):(14.05 + wT2offset))
		)
	    ))
	(pcLayer = 34)
	(pcPurpose = "drawing")
	(pcInst = dbCreateRect(pcCellView
		list(pcLayer pcPurpose)
		list(((11.525 + wR0offset):(13.65 + wT2offset))
		    ((11.925 + wR0offset):(14.05 + wT2offset))
		)
	    ))
	(pcLayer = 34)
	(pcPurpose = "drawing")
	(pcInst = dbCreateRect(pcCellView
		list(pcLayer pcPurpose)
		list(((12.35 + wR0offset):(13.65 + wT2offset))
		    ((12.75 + wR0offset):(14.05 + wT2offset))
		)
	    ))
	(pcLayer = 34)
	(pcPurpose = "drawing")
	(pcInst = dbCreateRect(pcCellView
		list(pcLayer pcPurpose)
		list(((13.175 + wR0offset):(13.65 + wT2offset))
		    ((13.575 + wR0offset):(14.05 + wT2offset))
		)
	    ))
	(pcLayer = 34)
	(pcPurpose = "drawing")
	(pcInst = dbCreateRect(pcCellView
		list(pcLayer pcPurpose)
		list(((14.0 + wR0offset):(13.65 + wT2offset))
		    ((14.4 + wR0offset):(14.05 + wT2offset))
		)
	    ))
	(pcLayer = 34)
	(pcPurpose = "drawing")
	(pcInst = dbCreateRect(pcCellView
		list(pcLayer pcPurpose)
		list(((14.0 + wR0offset):(0.15 - wB3offset))
		    ((14.4 + wR0offset):(0.55 - wB3offset))
		)
	    ))
	(pcLayer = 34)
	(pcPurpose = "drawing")
	(pcInst = dbCreateRect(pcCellView
		list(pcLayer pcPurpose)
		list(((14.0 + wR0offset):(0.975 - wB3offset))
		    ((14.4 + wR0offset):(1.375 - wB3offset))
		)
	    ))
	(pcLayer = 34)
	(pcPurpose = "drawing")
	(pcInst = dbCreateRect(pcCellView
		list(pcLayer pcPurpose)
		list(((14.0 + wR0offset):(1.8 - wB3offset))
		    ((14.4 + wR0offset):(2.2 - wB3offset))
		)
	    ))
	(pcLayer = 34)
	(pcPurpose = "drawing")
	(pcInst = dbCreateRect(pcCellView
		list(pcLayer pcPurpose)
		list(((14.0 + wR0offset):(2.625 - wB3offset))
		    ((14.4 + wR0offset):3.025)
		)
	    ))
	(pcLayer = 34)
	(pcPurpose = "drawing")
	(pcInst = dbCreateRect(pcCellView
		list(pcLayer pcPurpose)
		list(((14.0 + wR0offset):3.45)
		    ((14.4 + wR0offset):3.85)
		)
	    ))
	(pcLayer = 34)
	(pcPurpose = "drawing")
	(pcInst = dbCreateRect(pcCellView
		list(pcLayer pcPurpose)
		list(((14.0 + wR0offset):4.3)
		    ((14.4 + wR0offset):4.7)
		)
	    ))
	(pcLayer = 34)
	(pcPurpose = "drawing")
	(pcInst = dbCreateRect(pcCellView
		list(pcLayer pcPurpose)
		list(((14.0 + wR0offset):5.15)
		    ((14.4 + wR0offset):5.55)
		)
	    ))
	(pcLayer = 34)
	(pcPurpose = "drawing")
	(pcInst = dbCreateRect(pcCellView
		list(pcLayer pcPurpose)
		list(((14.0 + wR0offset):6.0)
		    ((14.4 + wR0offset):6.4)
		)
	    ))
	(pcLayer = 34)
	(pcPurpose = "drawing")
	(pcInst = dbCreateRect(pcCellView
		list(pcLayer pcPurpose)
		list(((14.0 + wR0offset):6.85)
		    ((14.4 + wR0offset):7.25)
		)
	    ))
	(pcLayer = 34)
	(pcPurpose = "drawing")
	(pcInst = dbCreateRect(pcCellView
		list(pcLayer pcPurpose)
		list(((14.0 + wR0offset):7.7)
		    ((14.4 + wR0offset):8.1)
		)
	    ))
	(pcLayer = 34)
	(pcPurpose = "drawing")
	(pcInst = dbCreateRect(pcCellView
		list(pcLayer pcPurpose)
		list(((14.0 + wR0offset):8.550000000000001)
		    ((14.4 + wR0offset):8.949999999999999)
		)
	    ))
	(pcLayer = 34)
	(pcPurpose = "drawing")
	(pcInst = dbCreateRect(pcCellView
		list(pcLayer pcPurpose)
		list(((14.0 + wR0offset):9.4)
		    ((14.4 + wR0offset):9.800000000000001)
		)
	    ))
	(pcLayer = 34)
	(pcPurpose = "drawing")
	(pcInst = dbCreateRect(pcCellView
		list(pcLayer pcPurpose)
		list(((14.0 + wR0offset):10.25)
		    ((14.4 + wR0offset):10.65)
		)
	    ))
	(pcLayer = 34)
	(pcPurpose = "drawing")
	(pcInst = dbCreateRect(pcCellView
		list(pcLayer pcPurpose)
		list(((14.0 + wR0offset):11.1)
		    ((14.4 + wR0offset):(11.5 + wT2offset))
		)
	    ))
	(pcLayer = 34)
	(pcPurpose = "drawing")
	(pcInst = dbCreateRect(pcCellView
		list(pcLayer pcPurpose)
		list(((14.0 + wR0offset):(11.95 + wT2offset))
		    ((14.4 + wR0offset):(12.35 + wT2offset))
		)
	    ))
	(pcLayer = 34)
	(pcPurpose = "drawing")
	(pcInst = dbCreateRect(pcCellView
		list(pcLayer pcPurpose)
		list(((14.0 + wR0offset):(12.8 + wT2offset))
		    ((14.4 + wR0offset):(13.2 + wT2offset))
		)
	    ))
	(pcLayer = 34)
	(pcPurpose = "drawing")
	(pcInst = dbCreateRect(pcCellView
		list(pcLayer pcPurpose)
		list(((14.0 + wR0offset):(13.65 + wT2offset))
		    ((14.4 + wR0offset):(14.05 + wT2offset))
		)
	    ))
	(pcLayer = 34)
	(pcPurpose = "drawing")
	(pcInst = dbCreateRect(pcCellView
		list(pcLayer pcPurpose)
		list(((14.0 + wR0offset):(0.15 - wB3offset))
		    ((14.4 + wR0offset):(0.55 - wB3offset))
		)
	    ))
	(pcLayer = 34)
	(pcPurpose = "drawing")
	(pcInst = dbCreateRect(pcCellView
		list(pcLayer pcPurpose)
		list(((13.2 + wR0offset):(0.15 - wB3offset))
		    ((13.6 + wR0offset):(0.55 - wB3offset))
		)
	    ))
	(pcLayer = 34)
	(pcPurpose = "drawing")
	(pcInst = dbCreateRect(pcCellView
		list(pcLayer pcPurpose)
		list(((12.4 + wR0offset):(0.15 - wB3offset))
		    ((12.8 + wR0offset):(0.55 - wB3offset))
		)
	    ))
	(pcLayer = 34)
	(pcPurpose = "drawing")
	(pcInst = dbCreateRect(pcCellView
		list(pcLayer pcPurpose)
		list(((11.6 + wR0offset):(0.15 - wB3offset))
		    ((12.0 + wR0offset):(0.55 - wB3offset))
		)
	    ))
	(pcLayer = 34)
	(pcPurpose = "drawing")
	(pcInst = dbCreateRect(pcCellView
		list(pcLayer pcPurpose)
		list(((10.8 + wR0offset):(0.15 - wB3offset))
		    ((11.2 + wR0offset):(0.55 - wB3offset))
		)
	    ))
	(pcLayer = 34)
	(pcPurpose = "drawing")
	(pcInst = dbCreateRect(pcCellView
		list(pcLayer pcPurpose)
		list((10.0:(0.15 - wB3offset))
		    (10.4:(0.55 - wB3offset))
		)
	    ))
	(pcLayer = 34)
	(pcPurpose = "drawing")
	(pcInst = dbCreateRect(pcCellView
		list(pcLayer pcPurpose)
		list((9.199999999999999:(0.15 - wB3offset))
		    (9.6:(0.55 - wB3offset))
		)
	    ))
	(pcLayer = 34)
	(pcPurpose = "drawing")
	(pcInst = dbCreateRect(pcCellView
		list(pcLayer pcPurpose)
		list((8.4:(0.15 - wB3offset))
		    (8.800000000000001:(0.55 - wB3offset))
		)
	    ))
	(pcLayer = 34)
	(pcPurpose = "drawing")
	(pcInst = dbCreateRect(pcCellView
		list(pcLayer pcPurpose)
		list((7.575:(0.15 - wB3offset))
		    (7.975:(0.55 - wB3offset))
		)
	    ))
	(pcLayer = 34)
	(pcPurpose = "drawing")
	(pcInst = dbCreateRect(pcCellView
		list(pcLayer pcPurpose)
		list((6.75:(0.15 - wB3offset))
		    (7.15:(0.55 - wB3offset))
		)
	    ))
	(pcLayer = 34)
	(pcPurpose = "drawing")
	(pcInst = dbCreateRect(pcCellView
		list(pcLayer pcPurpose)
		list((5.925:(0.15 - wB3offset))
		    (6.325:(0.55 - wB3offset))
		)
	    ))
	(pcLayer = 34)
	(pcPurpose = "drawing")
	(pcInst = dbCreateRect(pcCellView
		list(pcLayer pcPurpose)
		list((5.1:(0.15 - wB3offset))
		    (5.5:(0.55 - wB3offset))
		)
	    ))
	(pcLayer = 34)
	(pcPurpose = "drawing")
	(pcInst = dbCreateRect(pcCellView
		list(pcLayer pcPurpose)
		list((4.275:(0.15 - wB3offset))
		    (4.675:(0.55 - wB3offset))
		)
	    ))
	(pcLayer = 34)
	(pcPurpose = "drawing")
	(pcInst = dbCreateRect(pcCellView
		list(pcLayer pcPurpose)
		list((3.45:(0.15 - wB3offset))
		    (3.85:(0.55 - wB3offset))
		)
	    ))
	(pcLayer = 34)
	(pcPurpose = "drawing")
	(pcInst = dbCreateRect(pcCellView
		list(pcLayer pcPurpose)
		list(((2.625 - wL1offset):(0.15 - wB3offset))
		    ((3.025 - wL1offset):(0.55 - wB3offset))
		)
	    ))
	(pcLayer = 34)
	(pcPurpose = "drawing")
	(pcInst = dbCreateRect(pcCellView
		list(pcLayer pcPurpose)
		list(((1.8 - wL1offset):(0.15 - wB3offset))
		    ((2.2 - wL1offset):(0.55 - wB3offset))
		)
	    ))
	(pcLayer = 34)
	(pcPurpose = "drawing")
	(pcInst = dbCreateRect(pcCellView
		list(pcLayer pcPurpose)
		list(((0.975 - wL1offset):(0.15 - wB3offset))
		    ((1.375 - wL1offset):(0.55 - wB3offset))
		)
	    ))
	(pcLayer = 34)
	(pcPurpose = "drawing")
	(pcInst = dbCreateRect(pcCellView
		list(pcLayer pcPurpose)
		list(((0.15 - wL1offset):(0.15 - wB3offset))
		    ((0.55 - wL1offset):(0.55 - wB3offset))
		)
	    ))
	(pcLayer = 34)
	(pcPurpose = "drawing")
	(pcInst = dbCreateRect(pcCellView
		list(pcLayer pcPurpose)
		list(((18.7 + wR0offset):(1.825 - wB3offset))
		    ((19.1 + wR0offset):(2.225 - wB3offset))
		)
	    ))
	(pcLayer = 34)
	(pcPurpose = "drawing")
	(pcInst = dbCreateRect(pcCellView
		list(pcLayer pcPurpose)
		list(((18.7 + wR0offset):(2.625 - wB3offset))
		    ((19.1 + wR0offset):3.025)
		)
	    ))
	(pcLayer = 34)
	(pcPurpose = "drawing")
	(pcInst = dbCreateRect(pcCellView
		list(pcLayer pcPurpose)
		list(((18.7 + wR0offset):3.425)
		    ((19.1 + wR0offset):3.825)
		)
	    ))
	(pcLayer = 34)
	(pcPurpose = "drawing")
	(pcInst = dbCreateRect(pcCellView
		list(pcLayer pcPurpose)
		list(((18.7 + wR0offset):4.225)
		    ((19.1 + wR0offset):4.625)
		)
	    ))
	(pcLayer = 34)
	(pcPurpose = "drawing")
	(pcInst = dbCreateRect(pcCellView
		list(pcLayer pcPurpose)
		list(((18.7 + wR0offset):5.025)
		    ((19.1 + wR0offset):5.425)
		)
	    ))
	(pcLayer = 34)
	(pcPurpose = "drawing")
	(pcInst = dbCreateRect(pcCellView
		list(pcLayer pcPurpose)
		list(((18.7 + wR0offset):5.825)
		    ((19.1 + wR0offset):6.225)
		)
	    ))
	(pcLayer = 34)
	(pcPurpose = "drawing")
	(pcInst = dbCreateRect(pcCellView
		list(pcLayer pcPurpose)
		list(((18.7 + wR0offset):6.625)
		    ((19.1 + wR0offset):7.025)
		)
	    ))
	(pcLayer = 34)
	(pcPurpose = "drawing")
	(pcInst = dbCreateRect(pcCellView
		list(pcLayer pcPurpose)
		list(((18.7 + wR0offset):7.425)
		    ((19.1 + wR0offset):7.825)
		)
	    ))
	(pcLayer = 34)
	(pcPurpose = "drawing")
	(pcInst = dbCreateRect(pcCellView
		list(pcLayer pcPurpose)
		list(((18.7 + wR0offset):8.225)
		    ((19.1 + wR0offset):8.625)
		)
	    ))
	(pcLayer = 34)
	(pcPurpose = "drawing")
	(pcInst = dbCreateRect(pcCellView
		list(pcLayer pcPurpose)
		list(((18.7 + wR0offset):9.050000000000001)
		    ((19.1 + wR0offset):9.449999999999999)
		)
	    ))
	(pcLayer = 34)
	(pcPurpose = "drawing")
	(pcInst = dbCreateRect(pcCellView
		list(pcLayer pcPurpose)
		list(((18.7 + wR0offset):9.875)
		    ((19.1 + wR0offset):10.275)
		)
	    ))
	(pcLayer = 34)
	(pcPurpose = "drawing")
	(pcInst = dbCreateRect(pcCellView
		list(pcLayer pcPurpose)
		list(((18.7 + wR0offset):10.7)
		    ((19.1 + wR0offset):11.1)
		)
	    ))
	(pcLayer = 34)
	(pcPurpose = "drawing")
	(pcInst = dbCreateRect(pcCellView
		list(pcLayer pcPurpose)
		list(((0.15 - wL1offset):(13.65 + wT2offset))
		    ((0.55 - wL1offset):(14.05 + wT2offset))
		)
	    ))
	(pcLayer = 34)
	(pcPurpose = "drawing")
	(pcInst = dbCreateRect(pcCellView
		list(pcLayer pcPurpose)
		list(((0.15 - wL1offset):(12.825 + wT2offset))
		    ((0.55 - wL1offset):(13.225 + wT2offset))
		)
	    ))
	(pcLayer = 34)
	(pcPurpose = "drawing")
	(pcInst = dbCreateRect(pcCellView
		list(pcLayer pcPurpose)
		list(((0.15 - wL1offset):(12.0 + wT2offset))
		    ((0.55 - wL1offset):(12.4 + wT2offset))
		)
	    ))
	(pcLayer = 34)
	(pcPurpose = "drawing")
	(pcInst = dbCreateRect(pcCellView
		list(pcLayer pcPurpose)
		list(((0.15 - wL1offset):11.175)
		    ((0.55 - wL1offset):(11.575 + wT2offset))
		)
	    ))
	(pcLayer = 34)
	(pcPurpose = "drawing")
	(pcInst = dbCreateRect(pcCellView
		list(pcLayer pcPurpose)
		list(((0.15 - wL1offset):10.35)
		    ((0.55 - wL1offset):10.75)
		)
	    ))
	(pcLayer = 34)
	(pcPurpose = "drawing")
	(pcInst = dbCreateRect(pcCellView
		list(pcLayer pcPurpose)
		list(((0.15 - wL1offset):9.5)
		    ((0.55 - wL1offset):9.9)
		)
	    ))
	(pcLayer = 34)
	(pcPurpose = "drawing")
	(pcInst = dbCreateRect(pcCellView
		list(pcLayer pcPurpose)
		list(((0.15 - wL1offset):8.65)
		    ((0.55 - wL1offset):9.050000000000001)
		)
	    ))
	(pcLayer = 34)
	(pcPurpose = "drawing")
	(pcInst = dbCreateRect(pcCellView
		list(pcLayer pcPurpose)
		list(((0.15 - wL1offset):7.8)
		    ((0.55 - wL1offset):8.199999999999999)
		)
	    ))
	(pcLayer = 34)
	(pcPurpose = "drawing")
	(pcInst = dbCreateRect(pcCellView
		list(pcLayer pcPurpose)
		list(((0.15 - wL1offset):6.95)
		    ((0.55 - wL1offset):7.35)
		)
	    ))
	(pcLayer = 34)
	(pcPurpose = "drawing")
	(pcInst = dbCreateRect(pcCellView
		list(pcLayer pcPurpose)
		list(((0.15 - wL1offset):6.1)
		    ((0.55 - wL1offset):6.5)
		)
	    ))
	(pcLayer = 34)
	(pcPurpose = "drawing")
	(pcInst = dbCreateRect(pcCellView
		list(pcLayer pcPurpose)
		list(((0.15 - wL1offset):5.25)
		    ((0.55 - wL1offset):5.65)
		)
	    ))
	(pcLayer = 34)
	(pcPurpose = "drawing")
	(pcInst = dbCreateRect(pcCellView
		list(pcLayer pcPurpose)
		list(((0.15 - wL1offset):4.4)
		    ((0.55 - wL1offset):4.8)
		)
	    ))
	(pcLayer = 34)
	(pcPurpose = "drawing")
	(pcInst = dbCreateRect(pcCellView
		list(pcLayer pcPurpose)
		list(((0.15 - wL1offset):3.55)
		    ((0.55 - wL1offset):3.95)
		)
	    ))
	(pcLayer = 34)
	(pcPurpose = "drawing")
	(pcInst = dbCreateRect(pcCellView
		list(pcLayer pcPurpose)
		list(((0.15 - wL1offset):(2.7 - wB3offset))
		    ((0.55 - wL1offset):3.1)
		)
	    ))
	(pcLayer = 34)
	(pcPurpose = "drawing")
	(pcInst = dbCreateRect(pcCellView
		list(pcLayer pcPurpose)
		list(((0.15 - wL1offset):(1.85 - wB3offset))
		    ((0.55 - wL1offset):(2.25 - wB3offset))
		)
	    ))
	(pcLayer = 34)
	(pcPurpose = "drawing")
	(pcInst = dbCreateRect(pcCellView
		list(pcLayer pcPurpose)
		list(((0.15 - wL1offset):(1.0 - wB3offset))
		    ((0.55 - wL1offset):(1.4 - wB3offset))
		)
	    ))
	(pcLayer = 34)
	(pcPurpose = "drawing")
	(pcInst = dbCreateRect(pcCellView
		list(pcLayer pcPurpose)
		list(((0.15 - wL1offset):(0.15 - wB3offset))
		    ((0.55 - wL1offset):(0.55 - wB3offset))
		)
	    ))
	(pcLayer = 34)
	(pcPurpose = "drawing")
	(pcInst = dbCreateRect(pcCellView
		list(pcLayer pcPurpose)
		list(((1.3 - wL1offset):(1.3 - wB3offset))
		    ((1.7 - wL1offset):(1.7 - wB3offset))
		)
	    ))
	(pcLayer = 34)
	(pcPurpose = "drawing")
	(pcInst = dbCreateRect(pcCellView
		list(pcLayer pcPurpose)
		list(((1.3 - wL1offset):(2.1 - wB3offset))
		    ((1.7 - wL1offset):(2.5 - wB3offset))
		)
	    ))
	(pcLayer = 34)
	(pcPurpose = "drawing")
	(pcInst = dbCreateRect(pcCellView
		list(pcLayer pcPurpose)
		list(((1.3 - wL1offset):(2.9 - wB3offset))
		    ((1.7 - wL1offset):3.3)
		)
	    ))
	(pcLayer = 34)
	(pcPurpose = "drawing")
	(pcInst = dbCreateRect(pcCellView
		list(pcLayer pcPurpose)
		list(((1.3 - wL1offset):3.7)
		    ((1.7 - wL1offset):4.1)
		)
	    ))
	(pcLayer = 34)
	(pcPurpose = "drawing")
	(pcInst = dbCreateRect(pcCellView
		list(pcLayer pcPurpose)
		list(((1.3 - wL1offset):4.5)
		    ((1.7 - wL1offset):4.9)
		)
	    ))
	(pcLayer = 34)
	(pcPurpose = "drawing")
	(pcInst = dbCreateRect(pcCellView
		list(pcLayer pcPurpose)
		list(((1.3 - wL1offset):5.3)
		    ((1.7 - wL1offset):5.7)
		)
	    ))
	(pcLayer = 34)
	(pcPurpose = "drawing")
	(pcInst = dbCreateRect(pcCellView
		list(pcLayer pcPurpose)
		list(((1.3 - wL1offset):6.1)
		    ((1.7 - wL1offset):6.5)
		)
	    ))
	(pcLayer = 34)
	(pcPurpose = "drawing")
	(pcInst = dbCreateRect(pcCellView
		list(pcLayer pcPurpose)
		list(((1.3 - wL1offset):6.9)
		    ((1.7 - wL1offset):7.3)
		)
	    ))
	(pcLayer = 34)
	(pcPurpose = "drawing")
	(pcInst = dbCreateRect(pcCellView
		list(pcLayer pcPurpose)
		list(((1.3 - wL1offset):7.7)
		    ((1.7 - wL1offset):8.1)
		)
	    ))
	(pcLayer = 34)
	(pcPurpose = "drawing")
	(pcInst = dbCreateRect(pcCellView
		list(pcLayer pcPurpose)
		list(((1.3 - wL1offset):8.5)
		    ((1.7 - wL1offset):8.9)
		)
	    ))
	(pcLayer = 34)
	(pcPurpose = "drawing")
	(pcInst = dbCreateRect(pcCellView
		list(pcLayer pcPurpose)
		list(((1.3 - wL1offset):9.300000000000001)
		    ((1.7 - wL1offset):9.699999999999999)
		)
	    ))
	(pcLayer = 34)
	(pcPurpose = "drawing")
	(pcInst = dbCreateRect(pcCellView
		list(pcLayer pcPurpose)
		list(((1.3 - wL1offset):10.1)
		    ((1.7 - wL1offset):10.5)
		)
	    ))
	(pcLayer = 34)
	(pcPurpose = "drawing")
	(pcInst = dbCreateRect(pcCellView
		list(pcLayer pcPurpose)
		list(((1.3 - wL1offset):10.9)
		    ((1.7 - wL1offset):11.3)
		)
	    ))
	(pcLayer = 34)
	(pcPurpose = "drawing")
	(pcInst = dbCreateRect(pcCellView
		list(pcLayer pcPurpose)
		list(((1.3 - wL1offset):(11.7 + wT2offset))
		    ((1.7 - wL1offset):(12.1 + wT2offset))
		)
	    ))
	(pcLayer = 34)
	(pcPurpose = "drawing")
	(pcInst = dbCreateRect(pcCellView
		list(pcLayer pcPurpose)
		list(((1.3 - wL1offset):(12.5 + wT2offset))
		    ((1.7 - wL1offset):(12.9 + wT2offset))
		)
	    ))
	if(BottomCont then
	    (pcLayer = 30)
	    (pcPurpose = "drawing")
	    (pcInst = dbCreatePath(pcCellView
		    list(pcLayer pcPurpose)
		    list(((12.45 + wR0offset):(2.9 - wB3offset))
			((2.45 - wL1offset):(2.9 - wB3offset))
		    ) 1.6 "truncateExtend"
		))
	)
	if(LeftCont then
	    (pcLayer = 30)
	    (pcPurpose = "drawing")
	    (pcInst = dbCreatePath(pcCellView
		    list(pcLayer pcPurpose)
		    list(((3.25 - wL1offset):(12.1 + wT2offset))
			((3.25 - wL1offset):(2.1 - wB3offset))
		    ) 1.6 "truncateExtend"
		))
	)
	if(TopCont then
	    (pcLayer = 30)
	    (pcPurpose = "drawing")
	    (pcInst = dbCreatePath(pcCellView
		    list(pcLayer pcPurpose)
		    list(((2.45 - wL1offset):11.3)
			((12.45 + wR0offset):11.3)
		    ) 1.6 "truncateExtend"
		))
	)
	if(RightCont then
	    (pcLayer = 30)
	    (pcPurpose = "drawing")
	    (pcInst = dbCreatePath(pcCellView
		    list(pcLayer pcPurpose)
		    list(((11.65 + wR0offset):(2.1 - wB3offset))
			((11.65 + wR0offset):(12.1 + wT2offset))
		    ) 1.6 "truncateExtend"
		))
	)
	(pcLayer = 30)
	(pcPurpose = "drawing")
	(pcInst = dbCreateRect(pcCellView
		list(pcLayer pcPurpose)
		list(((2.45 - wL1offset):(2.1 - wB3offset))
		    ((12.45 + wR0offset):(12.1 + wT2offset))
		)
	    ))
	(pcLayer = 20)
	(pcPurpose = "drawing")
	(pcInst = dbCreateRect(pcCellView
		list(pcLayer pcPurpose)
		list(((1.1 - wL1offset):(1.1 - wB3offset))
		    ((13.45 + wR0offset):(13.1 + wT2offset))
		)
	    ))
	(pcLayer = 20)
	(pcPurpose = "drawing")
	(pcInst = dbCreatePath(pcCellView
		list(pcLayer pcPurpose)
		list(((18.9 + wR0offset):(11.45 + wT2offset))
		    ((18.9 + wR0offset):(1.475 - wB3offset))
		) 1.1 "truncateExtend"
	    ))
	(pcLayer = 20)
	(pcPurpose = "drawing")
	(pcInst = dbCreatePath(pcCellView
		list(pcLayer pcPurpose)
		list(((1.5 - wL1offset):(1.1 - wB3offset))
		    ((1.5 - wL1offset):(13.1 + wT2offset))
		) 0.8 "truncateExtend"
	    )) t
    )
)
