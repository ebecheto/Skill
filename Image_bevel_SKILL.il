pcDefinePCell(list(ddGetObj("Ed_CMOS8") "my_bevel_SKILL" "layout")
    ((sx float 0.0)
	(sy float 0.0)
    )
    let((sx sx0 sx0offset sy sy1
	    sy1offset pcMember pcStretchGroup stretchOffsetX stretchOffsetY
	    pcLib pcMaster pcInst pcTerm pcPin
	    pcPinName pcNet pcTermNet pcNetName pcTermNetName
	    pcMosaicInst pcParameters pcParamProp pcStep pcStepX
	    pcStepY pcRepeat pcRepeatX pcRepeatY pcIndexX
	    pcIndexY pcLayer pcPurpose pcLabelText pcLabelHeight
	    pcPropText pcParamText pcCoords pcPathWidth pcPolygonMargin
	)
	(pcLib = (pcCellView~>lib))
	(pcParameters = ((pcCellView~>parameters)~>value))
	(pcParamProp = car(exists(prop pcParameters
		    ((prop~>name) == "sx")
		)
	    ))
	(sx = (pcParamProp~>value))
	if(((pcParamProp~>valueType) == "boolean")
	    (sx = (sx == "TRUE"))
	)
	(pcParamProp = car(exists(prop pcParameters
		    ((prop~>name) == "sy")
		)
	    ))
	(sy = (pcParamProp~>value))
	if(((pcParamProp~>valueType) == "boolean")
	    (sy = (sy == "TRUE"))
	)
	(sx0 = sx)
	(sy1 = sy)
	(sx0offset = (sx0 - 673.08))
	(sy1offset = (sy1 - 1246.16))
	dbReplaceProp(pcCellView "function" "string" "transistor")
	dbReplaceProp(pcCellView "viewSubType" "string" "maskLayoutParamCell")
	(pcLayer = 32)
	(pcPurpose = "drawing")
	(pcInst = dbCreatePolygon(pcCellView
		list(pcLayer pcPurpose)
		list((125.16:0.16)
		    (0.16:125.16)
		    (0.16:(1375.16 + sy1offset))
		    (125.16:(1500.16 + sy1offset))
		    ((1475.16 + sx0offset):(1500.16 + sy1offset))
		    ((1600.16 + sx0offset):(1375.16 + sy1offset))
		    ((1600.16 + sx0offset):125.16)
		    ((1475.16 + sx0offset):0.16)
		)
	    ))
	(pcLayer = 0)
	(pcPurpose = "drawing")
	(pcInst = dbCreatePolygon(pcCellView
		list(pcLayer pcPurpose)
		list(((800.16 + sx0offset):4.56)
		    (126.98:4.56)
		    (4.56:126.98)
		    (4.56:(1373.34 + sy1offset))
		    (126.98:(1495.76 + sy1offset))
		    ((1473.34 + sx0offset):(1495.76 + sy1offset))
		    ((1595.76 + sx0offset):(1373.34 + sy1offset))
		    ((1595.76 + sx0offset):126.98)
		    ((1473.34 + sx0offset):4.56)
		    ((800.16 + sx0offset):4.56)
		    ((800.16 + sx0offset):0.16)
		    ((1475.16 + sx0offset):0.16)
		    ((1600.16 + sx0offset):125.16)
		    ((1600.16 + sx0offset):(1375.16 + sy1offset))
		    ((1475.16 + sx0offset):(1500.16 + sy1offset))
		    (125.16:(1500.16 + sy1offset))
		    (0.16:(1375.16 + sy1offset))
		    (0.16:125.16)
		    (125.16:0.16)
		    ((800.16 + sx0offset):0.16)
		)
	    ))
	(pcLayer = 48)
	(pcPurpose = "BAR")
	(pcInst = dbCreatePolygon(pcCellView
		list(pcLayer pcPurpose)
		list(((800.16 + sx0offset):2.86)
		    (126.28:2.86)
		    (2.86:126.28)
		    (2.86:(1374.04 + sy1offset))
		    (126.28:(1497.46 + sy1offset))
		    ((1474.04 + sx0offset):(1497.46 + sy1offset))
		    ((1597.46 + sx0offset):(1374.04 + sy1offset))
		    ((1597.46 + sx0offset):126.28)
		    ((1474.04 + sx0offset):2.86)
		    ((800.16 + sx0offset):2.86)
		    ((800.16 + sx0offset):1.86)
		    ((1474.46 + sx0offset):1.86)
		    ((1598.46 + sx0offset):125.86)
		    ((1598.46 + sx0offset):(1374.46 + sy1offset))
		    ((1474.46 + sx0offset):(1498.46 + sy1offset))
		    (125.86:(1498.46 + sy1offset))
		    (1.86:(1374.46 + sy1offset))
		    (1.86:125.86)
		    (125.86:1.86)
		    ((800.16 + sx0offset):1.86)
		)
	    ))
	(pcLayer = 85)
	(pcPurpose = "drawing")
	(pcInst = dbCreatePolygon(pcCellView
		list(pcLayer pcPurpose)
		list(((800.16 + sx0offset):4.8)
		    (127.08:4.8)
		    (4.8:127.08)
		    (4.8:(1373.24 + sy1offset))
		    (127.08:(1495.52 + sy1offset))
		    ((1473.24 + sx0offset):(1495.52 + sy1offset))
		    ((1595.52 + sx0offset):(1373.24 + sy1offset))
		    ((1595.52 + sx0offset):127.08)
		    ((1473.24 + sx0offset):4.8)
		    ((800.16 + sx0offset):4.8)
		    ((800.16 + sx0offset):0.36)
		    ((1475.08 + sx0offset):0.36)
		    ((1599.96 + sx0offset):125.24)
		    ((1599.96 + sx0offset):(1375.08 + sy1offset))
		    ((1475.08 + sx0offset):(1499.96 + sy1offset))
		    (125.24:(1499.96 + sy1offset))
		    (0.36:(1375.08 + sy1offset))
		    (0.36:125.24)
		    (125.24:0.36)
		    ((800.16 + sx0offset):0.36)
		)
	    ))
	(pcLayer = 122)
	(pcPurpose = "BAR")
	(pcInst = dbCreatePolygon(pcCellView
		list(pcLayer pcPurpose)
		list(((800.16 + sx0offset):3.2)
		    (126.42:3.2)
		    (3.2:126.42)
		    (3.2:(1373.9 + sy1offset))
		    (126.42:(1497.12 + sy1offset))
		    ((1473.9 + sx0offset):(1497.12 + sy1offset))
		    ((1597.12 + sx0offset):(1373.9 + sy1offset))
		    ((1597.12 + sx0offset):126.42)
		    ((1473.9 + sx0offset):3.2)
		    ((800.16 + sx0offset):3.2)
		    ((800.16 + sx0offset):1.96)
		    ((1474.41 + sx0offset):1.96)
		    ((1598.36 + sx0offset):125.91)
		    ((1598.36 + sx0offset):(1374.41 + sy1offset))
		    ((1474.41 + sx0offset):(1498.36 + sy1offset))
		    (125.91:(1498.36 + sy1offset))
		    (1.96:(1374.41 + sy1offset))
		    (1.96:125.91)
		    (125.91:1.96)
		    ((800.16 + sx0offset):1.96)
		)
	    ))
	(pcLayer = 47)
	(pcPurpose = "drawing")
	(pcInst = dbCreatePolygon(pcCellView
		list(pcLayer pcPurpose)
		list(((800.16 + sx0offset):4.8)
		    (127.08:4.8)
		    (4.8:127.08)
		    (4.8:(1373.24 + sy1offset))
		    (127.08:(1495.52 + sy1offset))
		    ((1473.24 + sx0offset):(1495.52 + sy1offset))
		    ((1595.52 + sx0offset):(1373.24 + sy1offset))
		    ((1595.52 + sx0offset):127.08)
		    ((1473.24 + sx0offset):4.8)
		    ((800.16 + sx0offset):4.8)
		    ((800.16 + sx0offset):0.36)
		    ((1475.08 + sx0offset):0.36)
		    ((1599.96 + sx0offset):125.24)
		    ((1599.96 + sx0offset):(1375.08 + sy1offset))
		    ((1475.08 + sx0offset):(1499.96 + sy1offset))
		    (125.24:(1499.96 + sy1offset))
		    (0.36:(1375.08 + sy1offset))
		    (0.36:125.24)
		    (125.24:0.36)
		    ((800.16 + sx0offset):0.36)
		)
	    ))
	(pcLayer = 121)
	(pcPurpose = "BAR")
	(pcInst = dbCreatePolygon(pcCellView
		list(pcLayer pcPurpose)
		list(((800.16 + sx0offset):3.2)
		    (126.42:3.2)
		    (3.2:126.42)
		    (3.2:(1373.9 + sy1offset))
		    (126.42:(1497.12 + sy1offset))
		    ((1473.9 + sx0offset):(1497.12 + sy1offset))
		    ((1597.12 + sx0offset):(1373.9 + sy1offset))
		    ((1597.12 + sx0offset):126.42)
		    ((1473.9 + sx0offset):3.2)
		    ((800.16 + sx0offset):3.2)
		    ((800.16 + sx0offset):1.96)
		    ((1474.41 + sx0offset):1.96)
		    ((1598.36 + sx0offset):125.91)
		    ((1598.36 + sx0offset):(1374.41 + sy1offset))
		    ((1474.41 + sx0offset):(1498.36 + sy1offset))
		    (125.91:(1498.36 + sy1offset))
		    (1.96:(1374.41 + sy1offset))
		    (1.96:125.91)
		    (125.91:1.96)
		    ((800.16 + sx0offset):1.96)
		)
	    ))
	(pcLayer = 123)
	(pcPurpose = "drawing")
	(pcInst = dbCreatePolygon(pcCellView
		list(pcLayer pcPurpose)
		list(((800.16 + sx0offset):4.8)
		    (127.08:4.8)
		    (4.8:127.08)
		    (4.8:(1373.24 + sy1offset))
		    (127.08:(1495.52 + sy1offset))
		    ((1473.24 + sx0offset):(1495.52 + sy1offset))
		    ((1595.52 + sx0offset):(1373.24 + sy1offset))
		    ((1595.52 + sx0offset):127.08)
		    ((1473.24 + sx0offset):4.8)
		    ((800.16 + sx0offset):4.8)
		    ((800.16 + sx0offset):0.36)
		    ((1475.08 + sx0offset):0.36)
		    ((1599.96 + sx0offset):125.24)
		    ((1599.96 + sx0offset):(1375.08 + sy1offset))
		    ((1475.08 + sx0offset):(1499.96 + sy1offset))
		    (125.24:(1499.96 + sy1offset))
		    (0.36:(1375.08 + sy1offset))
		    (0.36:125.24)
		    (125.24:0.36)
		    ((800.16 + sx0offset):0.36)
		)
	    ))
	(pcLayer = 114)
	(pcPurpose = "drawing")
	(pcInst = dbCreatePolygon(pcCellView
		list(pcLayer pcPurpose)
		list(((800.16 + sx0offset):4.8)
		    (127.08:4.8)
		    (4.8:127.08)
		    (4.8:(1373.24 + sy1offset))
		    (127.08:(1495.52 + sy1offset))
		    ((1473.24 + sx0offset):(1495.52 + sy1offset))
		    ((1595.52 + sx0offset):(1373.24 + sy1offset))
		    ((1595.52 + sx0offset):127.08)
		    ((1473.24 + sx0offset):4.8)
		    ((800.16 + sx0offset):4.8)
		    ((800.16 + sx0offset):0.36)
		    ((1475.08 + sx0offset):0.36)
		    ((1599.96 + sx0offset):125.24)
		    ((1599.96 + sx0offset):(1375.08 + sy1offset))
		    ((1475.08 + sx0offset):(1499.96 + sy1offset))
		    (125.24:(1499.96 + sy1offset))
		    (0.36:(1375.08 + sy1offset))
		    (0.36:125.24)
		    (125.24:0.36)
		    ((800.16 + sx0offset):0.36)
		)
	    ))
	(pcLayer = 109)
	(pcPurpose = "drawing")
	(pcInst = dbCreatePolygon(pcCellView
		list(pcLayer pcPurpose)
		list(((800.16 + sx0offset):2.56)
		    (126.15:2.56)
		    (2.56:126.15)
		    (2.56:(1374.17 + sy1offset))
		    (126.15:(1497.76 + sy1offset))
		    ((1474.17 + sx0offset):(1497.76 + sy1offset))
		    ((1597.76 + sx0offset):(1374.17 + sy1offset))
		    ((1597.76 + sx0offset):126.15)
		    ((1474.17 + sx0offset):2.56)
		    ((800.16 + sx0offset):2.56)
		    ((800.16 + sx0offset):2.16)
		    ((1474.33 + sx0offset):2.16)
		    ((1598.16 + sx0offset):125.99)
		    ((1598.16 + sx0offset):(1374.33 + sy1offset))
		    ((1474.33 + sx0offset):(1498.16 + sy1offset))
		    (125.99:(1498.16 + sy1offset))
		    (2.16:(1374.33 + sy1offset))
		    (2.16:125.99)
		    (125.99:2.16)
		    ((800.16 + sx0offset):2.16)
		)
	    ))
	(pcLayer = 12)
	(pcPurpose = "drawing")
	(pcInst = dbCreatePolygon(pcCellView
		list(pcLayer pcPurpose)
		list(((800.16 + sx0offset):4.36)
		    (126.9:4.36)
		    (4.36:126.9)
		    (4.36:(1373.42 + sy1offset))
		    (126.9:(1495.96 + sy1offset))
		    ((1473.42 + sx0offset):(1495.96 + sy1offset))
		    ((1595.96 + sx0offset):(1373.42 + sy1offset))
		    ((1595.96 + sx0offset):126.9)
		    ((1473.42 + sx0offset):4.36)
		    ((800.16 + sx0offset):4.36)
		    ((800.16 + sx0offset):0.36)
		    ((1475.08 + sx0offset):0.36)
		    ((1599.96 + sx0offset):125.24)
		    ((1599.96 + sx0offset):(1375.08 + sy1offset))
		    ((1475.08 + sx0offset):(1499.96 + sy1offset))
		    (125.24:(1499.96 + sy1offset))
		    (0.36:(1375.08 + sy1offset))
		    (0.36:125.24)
		    (125.24:0.36)
		    ((800.16 + sx0offset):0.36)
		)
	    ))
	(pcLayer = 14)
	(pcPurpose = "drawing")
	(pcInst = dbCreatePolygon(pcCellView
		list(pcLayer pcPurpose)
		list(((800.16 + sx0offset):2.46)
		    (126.11:2.46)
		    (2.46:126.11)
		    (2.46:(1374.21 + sy1offset))
		    (126.11:(1497.86 + sy1offset))
		    ((1474.21 + sx0offset):(1497.86 + sy1offset))
		    ((1597.86 + sx0offset):(1374.21 + sy1offset))
		    ((1597.86 + sx0offset):126.11)
		    ((1474.21 + sx0offset):2.46)
		    ((800.16 + sx0offset):2.46)
		    ((800.16 + sx0offset):2.26)
		    ((1474.29 + sx0offset):2.26)
		    ((1598.06 + sx0offset):126.03)
		    ((1598.06 + sx0offset):(1374.29 + sy1offset))
		    ((1474.29 + sx0offset):(1498.06 + sy1offset))
		    (126.03:(1498.06 + sy1offset))
		    (2.26:(1374.29 + sy1offset))
		    (2.26:126.03)
		    (126.03:2.26)
		    ((800.16 + sx0offset):2.26)
		)
	    ))
	(pcLayer = 15)
	(pcPurpose = "drawing")
	(pcInst = dbCreatePolygon(pcCellView
		list(pcLayer pcPurpose)
		list(((800.16 + sx0offset):4.36)
		    (126.9:4.36)
		    (4.36:126.9)
		    (4.36:(1373.42 + sy1offset))
		    (126.9:(1495.96 + sy1offset))
		    ((1473.42 + sx0offset):(1495.96 + sy1offset))
		    ((1595.96 + sx0offset):(1373.42 + sy1offset))
		    ((1595.96 + sx0offset):126.9)
		    ((1473.42 + sx0offset):4.36)
		    ((800.16 + sx0offset):4.36)
		    ((800.16 + sx0offset):0.36)
		    ((1475.08 + sx0offset):0.36)
		    ((1599.96 + sx0offset):125.24)
		    ((1599.96 + sx0offset):(1375.08 + sy1offset))
		    ((1475.08 + sx0offset):(1499.96 + sy1offset))
		    (125.24:(1499.96 + sy1offset))
		    (0.36:(1375.08 + sy1offset))
		    (0.36:125.24)
		    (125.24:0.36)
		    ((800.16 + sx0offset):0.36)
		)
	    ))
	(pcLayer = 17)
	(pcPurpose = "drawing")
	(pcInst = dbCreatePolygon(pcCellView
		list(pcLayer pcPurpose)
		list(((800.16 + sx0offset):2.46)
		    (126.11:2.46)
		    (2.46:126.11)
		    (2.46:(1374.21 + sy1offset))
		    (126.11:(1497.86 + sy1offset))
		    ((1474.21 + sx0offset):(1497.86 + sy1offset))
		    ((1597.86 + sx0offset):(1374.21 + sy1offset))
		    ((1597.86 + sx0offset):126.11)
		    ((1474.21 + sx0offset):2.46)
		    ((800.16 + sx0offset):2.46)
		    ((800.16 + sx0offset):2.26)
		    ((1474.29 + sx0offset):2.26)
		    ((1598.06 + sx0offset):126.03)
		    ((1598.06 + sx0offset):(1374.29 + sy1offset))
		    ((1474.29 + sx0offset):(1498.06 + sy1offset))
		    (126.03:(1498.06 + sy1offset))
		    (2.26:(1374.29 + sy1offset))
		    (2.26:126.03)
		    (126.03:2.26)
		    ((800.16 + sx0offset):2.26)
		)
	    ))
	(pcLayer = 18)
	(pcPurpose = "drawing")
	(pcInst = dbCreatePolygon(pcCellView
		list(pcLayer pcPurpose)
		list(((800.16 + sx0offset):4.36)
		    (126.9:4.36)
		    (4.36:126.9)
		    (4.36:(1373.42 + sy1offset))
		    (126.9:(1495.96 + sy1offset))
		    ((1473.42 + sx0offset):(1495.96 + sy1offset))
		    ((1595.96 + sx0offset):(1373.42 + sy1offset))
		    ((1595.96 + sx0offset):126.9)
		    ((1473.42 + sx0offset):4.36)
		    ((800.16 + sx0offset):4.36)
		    ((800.16 + sx0offset):0.36)
		    ((1475.08 + sx0offset):0.36)
		    ((1599.96 + sx0offset):125.24)
		    ((1599.96 + sx0offset):(1375.08 + sy1offset))
		    ((1475.08 + sx0offset):(1499.96 + sy1offset))
		    (125.24:(1499.96 + sy1offset))
		    (0.36:(1375.08 + sy1offset))
		    (0.36:125.24)
		    (125.24:0.36)
		    ((800.16 + sx0offset):0.36)
		)
	    ))
	(pcLayer = 31)
	(pcPurpose = "guardrng")
	(pcInst = dbCreatePolygon(pcCellView
		list(pcLayer pcPurpose)
		list(((800.16 + sx0offset):4.8)
		    (127.08:4.8)
		    (4.8:127.08)
		    (4.8:(1373.24 + sy1offset))
		    (127.08:(1495.52 + sy1offset))
		    ((1473.24 + sx0offset):(1495.52 + sy1offset))
		    ((1595.52 + sx0offset):(1373.24 + sy1offset))
		    ((1595.52 + sx0offset):127.08)
		    ((1473.24 + sx0offset):4.8)
		    ((800.16 + sx0offset):4.8)
		    ((800.16 + sx0offset):0.36)
		    ((1475.08 + sx0offset):0.36)
		    ((1599.96 + sx0offset):125.24)
		    ((1599.96 + sx0offset):(1375.08 + sy1offset))
		    ((1475.08 + sx0offset):(1499.96 + sy1offset))
		    (125.24:(1499.96 + sy1offset))
		    (0.36:(1375.08 + sy1offset))
		    (0.36:125.24)
		    (125.24:0.36)
		    ((800.16 + sx0offset):0.36)
		)
	    ))
	(pcLayer = 11)
	(pcPurpose = "drawing")
	(pcInst = dbCreatePolygon(pcCellView
		list(pcLayer pcPurpose)
		list(((800.16 + sx0offset):2.66)
		    (126.2:2.66)
		    (2.66:126.2)
		    (2.66:(1374.12 + sy1offset))
		    (126.2:(1497.66 + sy1offset))
		    ((1474.12 + sx0offset):(1497.66 + sy1offset))
		    ((1597.66 + sx0offset):(1374.12 + sy1offset))
		    ((1597.66 + sx0offset):126.2)
		    ((1474.12 + sx0offset):2.66)
		    ((800.16 + sx0offset):2.66)
		    ((800.16 + sx0offset):2.5)
		    ((1474.19 + sx0offset):2.5)
		    ((1597.82 + sx0offset):126.13)
		    ((1597.82 + sx0offset):(1374.19 + sy1offset))
		    ((1474.19 + sx0offset):(1497.82 + sy1offset))
		    (126.13:(1497.82 + sy1offset))
		    (2.5:(1374.19 + sy1offset))
		    (2.5:126.13)
		    (126.13:2.5)
		    ((800.16 + sx0offset):2.5)
		)
	    ))
	(pcLayer = 7)
	(pcPurpose = "drawing")
	(pcInst = dbCreatePolygon(pcCellView
		list(pcLayer pcPurpose)
		list(((800.16 + sx0offset):4.72)
		    (127.05:4.72)
		    (4.72:127.05)
		    (4.72:(1373.27 + sy1offset))
		    (127.05:(1495.6 + sy1offset))
		    ((1473.27 + sx0offset):(1495.6 + sy1offset))
		    ((1595.6 + sx0offset):(1373.27 + sy1offset))
		    ((1595.6 + sx0offset):127.05)
		    ((1473.27 + sx0offset):4.72)
		    ((800.16 + sx0offset):4.72)
		    ((800.16 + sx0offset):0.0)
		    ((1475.23 + sx0offset):0.0)
		    ((1600.32 + sx0offset):125.09)
		    ((1600.32 + sx0offset):(1375.23 + sy1offset))
		    ((1475.23 + sx0offset):(1500.32 + sy1offset))
		    (125.09:(1500.32 + sy1offset))
		    (0.0:(1375.23 + sy1offset))
		    (0.0:125.09)
		    (125.09:0.0)
		    ((800.16 + sx0offset):0.0)
		)
	    ))
	(pcLayer = 45)
	(pcPurpose = "drawing")
	(pcInst = dbCreatePolygon(pcCellView
		list(pcLayer pcPurpose)
		list((0.16:0.16)
		    (0.16:125.16)
		    (125.16:0.16)
		)
	    ))
	(pcLayer = 45)
	(pcPurpose = "drawing")
	(pcInst = dbCreatePolygon(pcCellView
		list(pcLayer pcPurpose)
		list((0.16:(1500.16 + sy1offset))
		    (0.16:(1375.16 + sy1offset))
		    (125.16:(1500.16 + sy1offset))
		)
	    ))
	(pcLayer = 45)
	(pcPurpose = "drawing")
	(pcInst = dbCreatePolygon(pcCellView
		list(pcLayer pcPurpose)
		list(((1600.16 + sx0offset):(1500.16 + sy1offset))
		    ((1600.16 + sx0offset):(1375.16 + sy1offset))
		    ((1475.16 + sx0offset):(1500.16 + sy1offset))
		)
	    ))
	(pcLayer = 45)
	(pcPurpose = "drawing")
	(pcInst = dbCreatePolygon(pcCellView
		list(pcLayer pcPurpose)
		list(((1600.16 + sx0offset):0.16)
		    ((1600.16 + sx0offset):125.16)
		    ((1475.16 + sx0offset):0.16)
		)
	    ))
	(pcLayer = 116)
	(pcPurpose = "drawing")
	(pcInst = dbCreatePolygon(pcCellView
		list(pcLayer pcPurpose)
		list(((800.16 + sx0offset):2.56)
		    (126.15:2.56)
		    (2.56:126.15)
		    (2.56:(1374.17 + sy1offset))
		    (126.15:(1497.76 + sy1offset))
		    ((1474.17 + sx0offset):(1497.76 + sy1offset))
		    ((1597.76 + sx0offset):(1374.17 + sy1offset))
		    ((1597.76 + sx0offset):126.15)
		    ((1474.17 + sx0offset):2.56)
		    ((800.16 + sx0offset):2.56)
		    ((800.16 + sx0offset):2.16)
		    ((1474.33 + sx0offset):2.16)
		    ((1598.16 + sx0offset):125.99)
		    ((1598.16 + sx0offset):(1374.33 + sy1offset))
		    ((1474.33 + sx0offset):(1498.16 + sy1offset))
		    (125.99:(1498.16 + sy1offset))
		    (2.16:(1374.33 + sy1offset))
		    (2.16:125.99)
		    (125.99:2.16)
		    ((800.16 + sx0offset):2.16)
		)
	    ))
	(pcLayer = 81)
	(pcPurpose = "drawing")
	(pcInst = dbCreatePolygon(pcCellView
		list(pcLayer pcPurpose)
		list(((800.16 + sx0offset):4.36)
		    (126.9:4.36)
		    (4.36:126.9)
		    (4.36:(1373.42 + sy1offset))
		    (126.9:(1495.96 + sy1offset))
		    ((1473.42 + sx0offset):(1495.96 + sy1offset))
		    ((1595.96 + sx0offset):(1373.42 + sy1offset))
		    ((1595.96 + sx0offset):126.9)
		    ((1473.42 + sx0offset):4.36)
		    ((800.16 + sx0offset):4.36)
		    ((800.16 + sx0offset):0.36)
		    ((1475.08 + sx0offset):0.36)
		    ((1599.96 + sx0offset):125.24)
		    ((1599.96 + sx0offset):(1375.08 + sy1offset))
		    ((1475.08 + sx0offset):(1499.96 + sy1offset))
		    (125.24:(1499.96 + sy1offset))
		    (0.36:(1375.08 + sy1offset))
		    (0.36:125.24)
		    (125.24:0.36)
		    ((800.16 + sx0offset):0.36)
		)
	    )) t
    )
)
