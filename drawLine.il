;; copyleft ebecheto

; load("drawLine.il")
dbCreateLine( geGetWindowCellView() list("text" "drawing1") list(-0.5:-100 100:-100))
leSetLayerValid('("text" "drawing1") t) ;=> Make layer selectable
