ineed('geOpenOrRaise)

defun(geOpenOrRaisecv (@optional (cv geGetWindowCellView()))
geOpenOrRaise(?cell cv~>cellName ?lib cv~>libName ?view cv~>viewName))
