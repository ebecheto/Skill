;===============================================================================
;   File Name     : CCStoggleDcOpPoints.ils
;   Date Created  : 11th July 2003
;   Group         : Custom IC, Cadence Design Systems Limited.
;   Language      : SKILL
;
;   Last Modified : 11th July 2003
;   Revision No.  : 1.1
;
;   Description   : This code will toggle the display of DC operating
;                   point annotation, and back to design defaults.
;                   The code is SKILL++ - this means that you should keep
;                   The .ils suffix to ensure that the lexical scoping
;                   is maintained. The reason for this is that the
;                   toggle status is maintained in dcOpPoint, a lexically
;                   scoped variable, which avoids the need for a global
;                   variable.
;
;   How to Run    : Assign a bindkey, for example:
;
;                   hiSetBindKey("Schematics" "<Key>t" "CCStoggleDcOpPoints()")
;
;                   Then, having run a DC operating point simulation,
;                   hit the t key to turn the operating point info on or off.
;
;   Side Effects  : Because the code does not find out whether the
;                   operating point info is currently annotated or not (because
;                   this is hard to do reliably), it keeps its own status.
;                   This means that if you annotate the DC operating point
;                   information from the menus, and then use the bindkey above,
;                   it may turn on DC operating point annotation when they
;                   are already displayed. However, pressing the key again
;                   will get the status back in sync.
;
;   Tested in     : IC50
;   SKILL Lint Score IC50 (Max=100) : 100
;     To get SKILL Lint to give this score, you need to do:
;       skIgnoreMessage('STRICT)
;       use prefixes CCS and toggle
;       This is because SKILL Lint does not handle SKILL++ code
;       correctly - it thinks that toggleDcOp is a global variable, which
;       it isn't. Similarly, CCStoggleDcOpPoints is a function name.
;===============================================================================

let((dcOpPoint)
    procedure(toggleDcOp(@optional (window hiGetCurrentWindow()))
        sevAnnotateResults(
            sevSession(window)
            if(dcOpPoint 'defaults 'dcOpPoints)
            )
        dcOpPoint=!dcOpPoint
        )
    CCStoggleDcOpPoints=toggleDcOp
    )

; cdfGetUserCellCDF( ddGetObj( "PRIMLIB" "pmos4"))~>opPointLabelSet = "vgs vth gm gds vdsat vds"

;; cdfGetUserCellCDF( ddGetObj( "PRIMLIB" "pmos4"))~>opPointLabelSet = "vgs vth vdsat vds gds ids region"
;; cdfGetUserCellCDF( ddGetObj( "PRIMLIB" "nmos4"))~>opPointLabelSet = "vgs vth vdsat vds gds ids region"

;;; hiSetBindKey("Schematics" "<Shift><Key>t" "cdfGetUserCellCDF( ddGetObj( \"PRIMLIB\" \"pmos4\"))~>opPointLabelSet = \"id vgs vds region\"")

;; sevAnnotateResults(hiGetCurrentWindow() 'tranOpPoints)
;hiSetBindKey("Schematics" "<Key>t" "CCStoggleDcOpPoints()")

;;;;;sevAnnotateResults(asiGetCurrentSession()~>data~>sevSession  'dcOpPoints)
;;sevAnnotateResults(asiGetCurrentSession()~>data~>sevSession 'componentParameters)
;;sevAnnotateResults(asiGetCurrentSession()~>data~>sevSession 'dcOpPoints)
;;sevAnnotateResults(asiGetCurrentSession()~>data~>sevSession 'modelParameters)
;;sevAnnotateResults(asiGetCurrentSession()~>data~>sevSession 'dcNodeVoltages)
;;sevAnnotateResults(asiGetCurrentSession()~>data~>sevSession 'tranNodeVoltages) ;;<== open a pop up menu that ask for the tran-time to choose

;; sevAnnotateResults(asiGetCurrentSession()~>data~>sevSession 'netNames)
; 'componentParameters, 'modelParameters, 'dcOpPoints, 'tranOpPoints, 'netNames, 'dcNodeVoltages, 'tranNodeVoltages, 'defaults, 'dcTermCurrent, or 'voltageLevels.

;;hiGetCurrentWindow()->sevSession <== donne 'sevSession3
/*******************************************************************************
*  DISCLAIMER: The following code is provided for Cadence customers to use at  *
*   their own risk. The code may require modification to satisfy the           *
*   requirements of any user. The code and any modifications to the code may   *
*   not be compatible with current or future versions of Cadence products.     *
*   THE CODE IS PROVIDED "AS IS" AND WITH NO WARRANTIES, INCLUDING WITHOUT     *
*   LIMITATION ANY EXPRESS WARRANTIES OR IMPLIED WARRANTIES OF MERCHANTABILITY *
*   OR FITNESS FOR A PARTICULAR USE.                                           *
*******************************************************************************/
