;load "~/time_stamp/ocn_dll_mem/opt_inv_4_2.ocn"

ocnWaveformTool( 'wavescan )
simulator( 'spectre )
design(	 "/home/vallerand/time_stamp/Sim/sim_clock_generator_4_2/spectre/schematic/netlist/netlist")
resultsDir( "/home/vallerand/time_stamp/Sim/sim_clock_generator_4_2/spectre/schematic" )
modelFile(
    '("/cds/AMS3.70/spectre/c35/mcparams.scs" "")
    '("/cds/AMS3.70/spectre/c35/cmos53.scs" "cmostm")
    '("/cds/AMS3.70/spectre/c35/res.scs" "restm")
    '("/cds/AMS3.70/spectre/c35/cap.scs" "captm")
    '("/cds/AMS3.70/spectre/c35/bip.scs" "biptm")
    '("/cds/AMS3.70/spectre/c35/ind.scs" "indtm")
)
analysis('tran ?stop "15n"  )
analysis('dc ?saveOppoint t  )
desVar(	  "wp_I" 8u	)
desVar(	  "wn_inv2" 2.8u	)
desVar(	  "wn_inv1" 2.8u	)
desVar(	  "wn_I" 2u	)
desVar(	  "coef" 1	)
desVar(	  "c_np2" 2.5	)
desVar(	  "c_np" 2.5	)
desVar(	  "wp" 6.3u	)
desVar(	  "wn" 1u	)
desVar(	  "val_cap_i" 0	)
desVar(	  "val_cap" 20f	)
desVar(	  "v_3cells" 3.3	)
desVar(	  "v_2" 2.325	)
desVar(	  "r_load" 100k	)
desVar(	  "tw" 1.25n	)
desVar(	  "tt" 2.5n	)
desVar(	  "l" 0	)
converge( 'ic "/cp" "1.538" )
temp( 27 )
;	run()
delay_rise = delay(VT("/s_0") 1.65 2 "rising" VT("/s_1") 1.65 2 "rising")
plot( delay_rise ?expr '( "delay_rise" ) )
delay_fall = delay(VT("/s_0") 1.65 2 "falling" VT("/s_1") 1.65 2 "falling")
plot( delay_fall ?expr '( "delay_fall" ) )
delay_cell1\-\>2_rise = delay(VT("/cell1") 1.65 2 "rising" VT("/cell_11") 1.65 2 "rising")
plot( delay_cell1\-\>2_rise ?expr '( "delay_cell1->2_rise" ) )
delay_cell1\-\>2_fall = delay(VT("/cell1") 1.65 2 "falling" VT("/cell_11") 1.65 2 "falling")
plot( delay_cell1\-\>2_fall ?expr '( "delay_cell1->2_fall" ) )

list_temp= list( 27)    ;-20 27 60

nom3 =list("1r" "1f" "2r" "2f" "3r" "3f" )

;nom3 =list("temp=60 degC" "temp=27 degC" "temp=-20 degC")

tab_tab_delay = nil
tab_delay_rise = nil
tab_delay_fall = nil

list_coef_np = list(1 2 3 )	;coef_np = list(1 1.5 2 2.5 3 4)

list_wnmos = list(1u 2u 3u 4u 6u 8u ) ; list_wn = list(0.5u 1u 1.5u 2u 3u 4u 5u 10u

clearAll()

foreach( coef_np list_coef_np
desVar(	  "c_np2" coef_np	)
desVar(	  "c_np" coef_np	)

foreach( wn list_wnmos

desVar(	  "wn_inv2" wn	)
desVar(	  "wn_inv1" wn	)

                run()
                selectResult( 'tran )

	fall  = delay(VT("/cell1") 1.65 2 "falling" VT("/cell_11") 1.65 2 "falling")

	rise =	delay(VT("/cell1") 1.65 2 "rising" VT("/cell_11") 1.65 2 "rising")

		tab_delay_rise = cons(rise tab_delay_rise)
                tab_delay_fall = cons(fall tab_delay_fall)

                )

                tab_delay_rise = reverse( tab_delay_rise);
                tab_delay_fall = reverse( tab_delay_fall);

                tab_tab_delay = cons(tab_delay_rise tab_tab_delay)
                tab_tab_delay = cons(tab_delay_fall tab_tab_delay)

                tab_delay_rise = nil;
                tab_delay_fall = nil;

                )

		 tab_tab_delay = reverse(tab_tab_delay)

                windowID3 = awvCreatePlotWindow()
                ;awvPlotList(windowID3 tab_tab_delay tab_tab_delay  ?subwindow 1 )

                awvPlotList(windowID3 tab_tab_delay list_wnmos  ?subwindow 1 ?expr
                nom3)

                awvPlaceWindowLabel( windowID3 list(0.2 0.95) "retard en s en fonction de vcontrol en A" nil ?height                9 )
