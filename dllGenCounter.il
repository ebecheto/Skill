defun(dllGenCounter (@optional (L 8) (halfAdderList nil)(mdl nil)(mde nil))
let(( mdl mde HAL cells cellName pins cv schs V0 Vnw Vsx V1 V2 V3 V4 pulse bBox xy)
unless(halfAdderList halfAdderList='(
("AND2_C" (("C_" 1 t) "C_" "S<" ))
("XOR2_C" ("C_"  "Sum_"  "S<"))
("DFF_E"  ("Q_" "Sb<" "Sum_" ("clk" nil) ))
("AND2_C" ("S<" ("C_0" nil)  "Q_" ))
))
unless(mdl mdl='("gnd!" "sx!" "nw!" "vdd!"))
unless(mde mde='("sx!" "gnd!" "nw!" "vdd!"))
HAL=foreach(mapcar h halfAdderList cond(
(rexMatchp("DFF" car(h)) append(list(car(h)) list(append(mde cadr(h)))))
(t  append(list(car(h)) list(append(mdl cadr(h)))))
))
; L=8
cells=dllGenMotifHA(L HAL '())
cellName=sprintf(nil "COUNT_%d-bit" L)
pins=cons('("C_0" "clk") list(list((sprintf nil "S<0:%d>" L-1) (sprintf nil "Sb<0:%d>" L-1) (sprintf nil "C_%d" L))))
cv=array2sch(cells 'ibm cellName reverse(pins))
schs=schematic2symbol(cv t t) ;=> ("COUNT_8-bit" "COUNT_8-bit_sim")
V0='("vdc" ("gnd!" "vdd!")(("vdc" "float" 1.2)))  ;=> getPropList()
Vnw='("vdc" ("gnd!" "nw!")(("vdc" "float" 1.2)))
Vsx='("vdc" ("gnd!" "nx!")(("vdc" "float" 0.0)))
V1='("vpwl" ("gnd!" "vstart") (("v2" "string" "1.8") ("v6" "string" "1.8") ("t6" "string" "21.1n") ("t5" "string" "21n") ("t4" "string" "20.1n") ("v3" "string" "1.8") ("t3" "string" "20n") ("t2" "string" "1.1n") ("t1" "string" "1n")))
V2='("vpulse" ("gnd!" "vclk") (("v2" "string" "1.8") ("tf" "string" "100.0f") ("tr" "string" "100.0f") ("per" "string" "1n")))
V3='("BUFFER_C" ("gnd!" "sx!" "nw!" "vdd!" "clk" "vclk"))
V4='("BUFFER_C" ("gnd!" "sx!" "nw!" "vdd!" "C_0" "vstart"))
pulse=list(list(V0 V1 V2 V3 V4))
bBox=caddr(schs)~>bBox ;=> ((-0.9 -0.65) (1.3 -0.24375))
xy=mapcar('plus car(bBox) '(0 -1))
array2sch(pulse cv~>libName cadr(schs) nil 0.4 0.4 t nil "a" xy)
))
