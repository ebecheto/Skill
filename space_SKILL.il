pcDefinePCell(list(ddGetObj("Ed_IC6") "space_SKILL" "layout")
    ((XS float 6.665)
	(xStrach float 340.45)
    )
    let((XS XS0 XS0offset xStrach xStrach1
	    xStrach1offset pcMember pcStretchGroup stretchOffsetX stretchOffsetY
	    pcLib pcMaster pcInst pcTerm pcPin
	    pcPinName pcNet pcTermNet pcNetName pcTermNetName
	    pcMosaicInst pcParameters pcParamProp pcStep pcStepX
	    pcStepY pcRepeat pcRepeatX pcRepeatY pcIndexX
	    pcIndexY pcLayer pcPurpose pcLabelText pcLabelHeight
	    pcPropText pcParamText pcCoords pcPathWidth pcPolygonMargin
	)
	(pcLib = (pcCellView~>lib))
	(pcParameters = ((pcCellView~>parameters)~>value))
	(pcParamProp = car(exists(prop pcParameters
		    ((prop~>name) == "XS")
		)
	    ))
	(XS = (pcParamProp~>value))
	if(((pcParamProp~>valueType) == "boolean")
	    (XS = (XS == "TRUE"))
	)
	(pcParamProp = car(exists(prop pcParameters
		    ((prop~>name) == "xStrach")
		)
	    ))
	(xStrach = (pcParamProp~>value))
	if(((pcParamProp~>valueType) == "boolean")
	    (xStrach = (xStrach == "TRUE"))
	)
	(XS0 = XS)
	(xStrach1 = xStrach)
	(XS0offset = (XS0 - 6.665))
	(xStrach1offset = (xStrach1 - 340.45))
	dbReplaceProp(pcCellView "function" "string" "transistor")
	dbReplaceProp(pcCellView "pin#" "int" 6)
	dbReplaceProp(pcCellView "viewSubType" "string" "maskLayoutParamCell")
	(pcNetName = "vdd3o!")
	(pcTermNet = dbMakeNet(pcCellView pcNetName nil))
	if(!(pcTerm = dbFindTermByName(pcCellView pcNetName)) then
	    (pcTerm = dbCreateTerm(pcTermNet pcNetName "jumper" 0))
	)
	(pcLayer = 39)
	(pcPurpose = "pin")
	(pcInst = dbCreateRect(pcCellView
		list(pcLayer pcPurpose)
		list((0.0:(183.0 + xStrach1offset))
		    ((0.1 + XS0offset):(257.6 + xStrach1offset))
		)
	    ))
	(pcPin = dbCreatePin(pcTermNet pcInst "I0|vdd3o!"))
	setSGq(pcPin
	    '("none") accessDir
	)
	if(!(pcTerm~>pins) then
	    dbDeleteObject(pcTerm)
	    if((!(pcTermNet~>figs) && !(pcTermNet~>instTerms)) then
		dbDeleteObject(pcTermNet)
	    )
	)
	(pcNetName = "vdd3r2!")
	(pcTermNet = dbMakeNet(pcCellView pcNetName nil))
	if(!(pcTerm = dbFindTermByName(pcCellView pcNetName)) then
	    (pcTerm = dbCreateTerm(pcTermNet pcNetName "jumper" 0))
	)
	(pcLayer = 39)
	(pcPurpose = "pin")
	(pcInst = dbCreateRect(pcCellView
		list(pcLayer pcPurpose)
		list((0.0:(261.1 + xStrach1offset))
		    ((0.1 + XS0offset):(286.1 + xStrach1offset))
		)
	    ))
	(pcPin = dbCreatePin(pcTermNet pcInst "I0|vdd3r2!"))
	setSGq(pcPin
	    '("none") accessDir
	)
	if(!(pcTerm~>pins) then
	    dbDeleteObject(pcTerm)
	    if((!(pcTermNet~>figs) && !(pcTermNet~>instTerms)) then
		dbDeleteObject(pcTermNet)
	    )
	)
	(pcNetName = "gnd3r!")
	(pcTermNet = dbMakeNet(pcCellView pcNetName nil))
	if(!(pcTerm = dbFindTermByName(pcCellView pcNetName)) then
	    (pcTerm = dbCreateTerm(pcTermNet pcNetName "jumper" 0))
	)
	(pcLayer = 39)
	(pcPurpose = "pin")
	(pcInst = dbCreateRect(pcCellView
		list(pcLayer pcPurpose)
		list((0.0:(288.0 + xStrach1offset))
		    ((0.1 + XS0offset):(318.0 + xStrach1offset))
		)
	    ))
	(pcPin = dbCreatePin(pcTermNet pcInst "I0|gnd3r!"))
	setSGq(pcPin
	    '("none") accessDir
	)
	if(!(pcTerm~>pins) then
	    dbDeleteObject(pcTerm)
	    if((!(pcTermNet~>figs) && !(pcTermNet~>instTerms)) then
		dbDeleteObject(pcTermNet)
	    )
	)
	(pcNetName = "vdd3r1!")
	(pcTermNet = dbMakeNet(pcCellView pcNetName nil))
	if(!(pcTerm = dbFindTermByName(pcCellView pcNetName)) then
	    (pcTerm = dbCreateTerm(pcTermNet pcNetName "jumper" 0))
	)
	(pcLayer = 39)
	(pcPurpose = "pin")
	(pcInst = dbCreateRect(pcCellView
		list(pcLayer pcPurpose)
		list((0.0:(319.85 + xStrach1offset))
		    ((0.1 + XS0offset):(339.85 + xStrach1offset))
		)
	    ))
	(pcPin = dbCreatePin(pcTermNet pcInst "I0|vdd3r1!"))
	setSGq(pcPin
	    '("none") accessDir
	)
	if(!(pcTerm~>pins) then
	    dbDeleteObject(pcTerm)
	    if((!(pcTermNet~>figs) && !(pcTermNet~>instTerms)) then
		dbDeleteObject(pcTermNet)
	    )
	)
	(pcNetName = "gnd3o!")
	(pcTermNet = dbMakeNet(pcCellView pcNetName nil))
	if(!(pcTerm = dbFindTermByName(pcCellView pcNetName)) then
	    (pcTerm = dbCreateTerm(pcTermNet pcNetName "jumper" 0))
	)
	(pcLayer = 39)
	(pcPurpose = "pin")
	(pcInst = dbCreateRect(pcCellView
		list(pcLayer pcPurpose)
		list((0.0:(105.4 + xStrach1offset))
		    ((0.1 + XS0offset):(180.0 + xStrach1offset))
		)
	    ))
	(pcPin = dbCreatePin(pcTermNet pcInst "I0|gnd3o!"))
	setSGq(pcPin
	    '("none") accessDir
	)
	if(!(pcTerm~>pins) then
	    dbDeleteObject(pcTerm)
	    if((!(pcTermNet~>figs) && !(pcTermNet~>instTerms)) then
		dbDeleteObject(pcTermNet)
	    )
	)
	(pcLayer = 35)
	(pcPurpose = "pin")
	(pcInst = dbCreateRect(pcCellView
		list(pcLayer pcPurpose)
		list((0.0:(0.0 + xStrach1offset))
		    ((0.1 + XS0offset):(0.5 + xStrach1offset))
		)
	    ))
	(pcLayer = 35)
	(pcPurpose = "pin")
	(pcInst = dbCreateRect(pcCellView
		list(pcLayer pcPurpose)
		list((0.0:(0.0 + xStrach1offset))
		    ((0.1 + XS0offset):(0.5 + xStrach1offset))
		)
	    ))
	(pcLayer = 42)
	(pcPurpose = "drawing")
	(pcInst = dbCreateRect(pcCellView
		list(pcLayer pcPurpose)
		list((0.0:(106.25 + xStrach1offset))
		    ((0.1 + XS0offset):(179.15 + xStrach1offset))
		)
	    ))
	(pcLayer = 42)
	(pcPurpose = "drawing")
	(pcInst = dbCreateRect(pcCellView
		list(pcLayer pcPurpose)
		list((0.0:(183.85 + xStrach1offset))
		    ((0.1 + XS0offset):(256.75 + xStrach1offset))
		)
	    ))
	(pcLayer = 42)
	(pcPurpose = "drawing")
	(pcInst = dbCreateRect(pcCellView
		list(pcLayer pcPurpose)
		list((0.0:(261.55 + xStrach1offset))
		    ((0.1 + XS0offset):(285.65 + xStrach1offset))
		)
	    ))
	(pcLayer = 42)
	(pcPurpose = "drawing")
	(pcInst = dbCreateRect(pcCellView
		list(pcLayer pcPurpose)
		list((0.0:(288.45 + xStrach1offset))
		    ((0.1 + XS0offset):(317.55 + xStrach1offset))
		)
	    ))
	(pcLayer = 42)
	(pcPurpose = "drawing")
	(pcInst = dbCreateRect(pcCellView
		list(pcLayer pcPurpose)
		list((0.0:(320.3 + xStrach1offset))
		    ((0.1 + XS0offset):(339.4 + xStrach1offset))
		)
	    ))
	(pcLayer = 230)
	(pcPurpose = "drawing")
	(pcLabelText = "Rev_B")
	(pcLabelHeight = 0.3)
	(pcInst = dbCreateLabel(pcCellView
		list(pcLayer pcPurpose)
		((0.1 + XS0offset):(1.7 + xStrach1offset)) pcLabelText "lowerLeft"
		"R0" "stick" pcLabelHeight
	    ))
	setSGq(pcInst "normalLabel" labelType)
	(pcLayer = 230)
	(pcPurpose = "drawing")
	(pcLabelText = "Owner: austriamicrosystems")
	(pcLabelHeight = 0.3)
	(pcInst = dbCreateLabel(pcCellView
		list(pcLayer pcPurpose)
		((0.1 + XS0offset):(0.5 + xStrach1offset)) pcLabelText "lowerLeft"
		"R0" "stick" pcLabelHeight
	    ))
	setSGq(pcInst "normalLabel" labelType)
	(pcLayer = 230)
	(pcPurpose = "drawing")
	(pcLabelText = "HIT-Kit: Digital")
	(pcLabelHeight = 0.3)
	(pcInst = dbCreateLabel(pcCellView
		list(pcLayer pcPurpose)
		((0.1 + XS0offset):(1.1 + xStrach1offset)) pcLabelText "lowerLeft"
		"R0" "stick" pcLabelHeight
	    ))
	setSGq(pcInst "normalLabel" labelType)
	(pcLayer = 35)
	(pcPurpose = "drawing")
	(pcInst = dbCreateRect(pcCellView
		list(pcLayer pcPurpose)
		list((0.0:(0.0 + xStrach1offset))
		    ((0.1 + XS0offset):(0.5 + xStrach1offset))
		)
	    ))
	(pcLayer = 8)
	(pcPurpose = "drawing")
	(pcInst = dbCreateRect(pcCellView
		list(pcLayer pcPurpose)
		list((-0.2:(108.6 + xStrach1offset))
		    ((0.3 + XS0offset):(169.4 + xStrach1offset))
		)
	    ))
	(pcLayer = 8)
	(pcPurpose = "drawing")
	(pcInst = dbCreateRect(pcCellView
		list(pcLayer pcPurpose)
		list((-0.2:(105.2 + xStrach1offset))
		    ((0.3 + XS0offset):(108.6 + xStrach1offset))
		)
	    ))
	(pcLayer = 8)
	(pcPurpose = "drawing")
	(pcInst = dbCreateRect(pcCellView
		list(pcLayer pcPurpose)
		list((-0.2:(264.15 + xStrach1offset))
		    ((0.3 + XS0offset):(284.3 + xStrach1offset))
		)
	    ))
	(pcLayer = 8)
	(pcPurpose = "drawing")
	(pcInst = dbCreateRect(pcCellView
		list(pcLayer pcPurpose)
		list((-0.2:(284.3 + xStrach1offset))
		    ((0.3 + XS0offset):(286.3 + xStrach1offset))
		)
	    ))
	(pcLayer = 8)
	(pcPurpose = "drawing")
	(pcInst = dbCreateRect(pcCellView
		list(pcLayer pcPurpose)
		list((-0.2:(262.15 + xStrach1offset))
		    ((0.3 + XS0offset):(264.15 + xStrach1offset))
		)
	    ))
	(pcLayer = 8)
	(pcPurpose = "drawing")
	(pcInst = dbCreateRect(pcCellView
		list(pcLayer pcPurpose)
		list((-0.2:(321.65 + xStrach1offset))
		    ((0.3 + XS0offset):(336.8 + xStrach1offset))
		)
	    ))
	(pcLayer = 8)
	(pcPurpose = "drawing")
	(pcInst = dbCreateRect(pcCellView
		list(pcLayer pcPurpose)
		list((-0.2:(319.65 + xStrach1offset))
		    ((0.3 + XS0offset):(321.65 + xStrach1offset))
		)
	    ))
	(pcLayer = 8)
	(pcPurpose = "drawing")
	(pcInst = dbCreateRect(pcCellView
		list(pcLayer pcPurpose)
		list((-0.2:(336.8 + xStrach1offset))
		    ((0.3 + XS0offset):(338.8 + xStrach1offset))
		)
	    ))
	(pcLayer = 8)
	(pcPurpose = "drawing")
	(pcInst = dbCreateRect(pcCellView
		list(pcLayer pcPurpose)
		list((-0.2:(169.4 + xStrach1offset))
		    ((0.3 + XS0offset):(172.8 + xStrach1offset))
		)
	    ))
	(pcLayer = 80)
	(pcPurpose = "drawing")
	(pcInst = dbCreateRect(pcCellView
		list(pcLayer pcPurpose)
		list((0.0:(0.0 + xStrach1offset))
		    ((0.1 + XS0offset):(340.4 + xStrach1offset))
		)
	    ))
	(pcLayer = 10)
	(pcPurpose = "drawing")
	(pcInst = dbCreateRect(pcCellView
		list(pcLayer pcPurpose)
		list((0.0:(105.4 + xStrach1offset))
		    ((0.1 + XS0offset):(172.6 + xStrach1offset))
		)
	    ))
	(pcLayer = 10)
	(pcPurpose = "drawing")
	(pcInst = dbCreateRect(pcCellView
		list(pcLayer pcPurpose)
		list((0.0:(177.9 + xStrach1offset))
		    ((0.1 + XS0offset):(261.15 + xStrach1offset))
		)
	    ))
	(pcLayer = 10)
	(pcPurpose = "drawing")
	(pcInst = dbCreateRect(pcCellView
		list(pcLayer pcPurpose)
		list((0.0:(288.0 + xStrach1offset))
		    ((0.1 + XS0offset):(289.0 + xStrach1offset))
		)
	    ))
	(pcLayer = 10)
	(pcPurpose = "drawing")
	(pcInst = dbCreateRect(pcCellView
		list(pcLayer pcPurpose)
		list((0.0:(285.1 + xStrach1offset))
		    ((0.1 + XS0offset):(286.1 + xStrach1offset))
		)
	    ))
	(pcLayer = 10)
	(pcPurpose = "drawing")
	(pcInst = dbCreateRect(pcCellView
		list(pcLayer pcPurpose)
		list((0.0:(258.15 + xStrach1offset))
		    ((0.1 + XS0offset):(261.15 + xStrach1offset))
		)
	    ))
	(pcLayer = 10)
	(pcPurpose = "drawing")
	(pcInst = dbCreateRect(pcCellView
		list(pcLayer pcPurpose)
		list((0.0:(262.35 + xStrach1offset))
		    ((0.1 + XS0offset):(263.35 + xStrach1offset))
		)
	    ))
	(pcLayer = 10)
	(pcPurpose = "drawing")
	(pcInst = dbCreateRect(pcCellView
		list(pcLayer pcPurpose)
		list((0.0:(337.6 + xStrach1offset))
		    ((0.1 + XS0offset):(338.6 + xStrach1offset))
		)
	    ))
	(pcLayer = 10)
	(pcPurpose = "drawing")
	(pcInst = dbCreateRect(pcCellView
		list(pcLayer pcPurpose)
		list((0.0:(319.85 + xStrach1offset))
		    ((0.1 + XS0offset):(320.85 + xStrach1offset))
		)
	    ))
	(pcLayer = 10)
	(pcPurpose = "drawing")
	(pcInst = dbCreateRect(pcCellView
		list(pcLayer pcPurpose)
		list((0.0:(317.0 + xStrach1offset))
		    ((0.1 + XS0offset):(318.0 + xStrach1offset))
		)
	    ))
	(pcLayer = 10)
	(pcPurpose = "drawing")
	(pcInst = dbCreateRect(pcCellView
		list(pcLayer pcPurpose)
		list((0.0:(169.6 + xStrach1offset))
		    ((0.1 + XS0offset):(172.6 + xStrach1offset))
		)
	    ))
	(pcLayer = 23)
	(pcPurpose = "drawing")
	(pcInst = dbCreateRect(pcCellView
		list(pcLayer pcPurpose)
		list((-0.25:(169.35 + xStrach1offset))
		    ((0.35 + XS0offset):(172.85 + xStrach1offset))
		)
	    ))
	(pcLayer = 23)
	(pcPurpose = "drawing")
	(pcInst = dbCreateRect(pcCellView
		list(pcLayer pcPurpose)
		list((-0.25:(105.15 + xStrach1offset))
		    ((0.35 + XS0offset):(172.85 + xStrach1offset))
		)
	    ))
	(pcLayer = 23)
	(pcPurpose = "drawing")
	(pcInst = dbCreateRect(pcCellView
		list(pcLayer pcPurpose)
		list((-0.25:(337.35 + xStrach1offset))
		    ((0.35 + XS0offset):(338.85 + xStrach1offset))
		)
	    ))
	(pcLayer = 23)
	(pcPurpose = "drawing")
	(pcInst = dbCreateRect(pcCellView
		list(pcLayer pcPurpose)
		list((-0.25:(319.6 + xStrach1offset))
		    ((0.35 + XS0offset):(321.1 + xStrach1offset))
		)
	    ))
	(pcLayer = 23)
	(pcPurpose = "drawing")
	(pcInst = dbCreateRect(pcCellView
		list(pcLayer pcPurpose)
		list((-0.25:(284.85 + xStrach1offset))
		    ((0.35 + XS0offset):(286.35 + xStrach1offset))
		)
	    ))
	(pcLayer = 23)
	(pcPurpose = "drawing")
	(pcInst = dbCreateRect(pcCellView
		list(pcLayer pcPurpose)
		list((-0.25:(262.1 + xStrach1offset))
		    ((0.35 + XS0offset):(263.6 + xStrach1offset))
		)
	    ))
	(pcLayer = 5)
	(pcPurpose = "drawing")
	(pcInst = dbCreateRect(pcCellView
		list(pcLayer pcPurpose)
		list((-0.2:(105.2 + xStrach1offset))
		    ((0.3 + XS0offset):(108.6 + xStrach1offset))
		)
	    ))
	(pcLayer = 5)
	(pcPurpose = "drawing")
	(pcInst = dbCreateRect(pcCellView
		list(pcLayer pcPurpose)
		list((-0.2:(108.6 + xStrach1offset))
		    ((0.3 + XS0offset):(169.4 + xStrach1offset))
		)
	    ))
	(pcLayer = 5)
	(pcPurpose = "drawing")
	(pcInst = dbCreateRect(pcCellView
		list(pcLayer pcPurpose)
		list((-0.2:(262.15 + xStrach1offset))
		    ((0.3 + XS0offset):(264.15 + xStrach1offset))
		)
	    ))
	(pcLayer = 5)
	(pcPurpose = "drawing")
	(pcInst = dbCreateRect(pcCellView
		list(pcLayer pcPurpose)
		list((-0.2:(284.3 + xStrach1offset))
		    ((0.3 + XS0offset):(286.3 + xStrach1offset))
		)
	    ))
	(pcLayer = 5)
	(pcPurpose = "drawing")
	(pcInst = dbCreateRect(pcCellView
		list(pcLayer pcPurpose)
		list((-0.2:(264.15 + xStrach1offset))
		    ((0.3 + XS0offset):(284.3 + xStrach1offset))
		)
	    ))
	(pcLayer = 5)
	(pcPurpose = "drawing")
	(pcInst = dbCreateRect(pcCellView
		list(pcLayer pcPurpose)
		list((-0.2:(336.8 + xStrach1offset))
		    ((0.3 + XS0offset):(338.8 + xStrach1offset))
		)
	    ))
	(pcLayer = 5)
	(pcPurpose = "drawing")
	(pcInst = dbCreateRect(pcCellView
		list(pcLayer pcPurpose)
		list((-0.2:(319.65 + xStrach1offset))
		    ((0.3 + XS0offset):(321.65 + xStrach1offset))
		)
	    ))
	(pcLayer = 5)
	(pcPurpose = "drawing")
	(pcInst = dbCreateRect(pcCellView
		list(pcLayer pcPurpose)
		list((-0.2:(321.65 + xStrach1offset))
		    ((0.3 + XS0offset):(336.8 + xStrach1offset))
		)
	    ))
	(pcLayer = 5)
	(pcPurpose = "drawing")
	(pcInst = dbCreateRect(pcCellView
		list(pcLayer pcPurpose)
		list((-0.2:(169.4 + xStrach1offset))
		    ((0.3 + XS0offset):(172.8 + xStrach1offset))
		)
	    ))
	(pcLayer = 39)
	(pcPurpose = "drawing")
	(pcInst = dbCreateRect(pcCellView
		list(pcLayer pcPurpose)
		list((0.0:(319.8 + xStrach1offset))
		    ((0.1 + XS0offset):(339.9 + xStrach1offset))
		)
	    ))
	(pcLayer = 39)
	(pcPurpose = "drawing")
	(pcInst = dbCreateRect(pcCellView
		list(pcLayer pcPurpose)
		list((0.0:(287.95 + xStrach1offset))
		    ((0.1 + XS0offset):(318.05 + xStrach1offset))
		)
	    ))
	(pcLayer = 39)
	(pcPurpose = "drawing")
	(pcInst = dbCreateRect(pcCellView
		list(pcLayer pcPurpose)
		list((0.0:(261.05 + xStrach1offset))
		    ((0.1 + XS0offset):(286.15 + xStrach1offset))
		)
	    ))
	(pcLayer = 39)
	(pcPurpose = "drawing")
	(pcInst = dbCreateRect(pcCellView
		list(pcLayer pcPurpose)
		list((0.0:(182.95 + xStrach1offset))
		    ((0.1 + XS0offset):(257.65 + xStrach1offset))
		)
	    ))
	(pcLayer = 39)
	(pcPurpose = "drawing")
	(pcInst = dbCreateRect(pcCellView
		list(pcLayer pcPurpose)
		list((0.0:(105.35 + xStrach1offset))
		    ((0.1 + XS0offset):(180.05 + xStrach1offset))
		)
	    ))
	(pcLayer = 24)
	(pcPurpose = "drawing")
	(pcInst = dbCreateRect(pcCellView
		list(pcLayer pcPurpose)
		list((-0.25:(316.75 + xStrach1offset))
		    ((0.35 + XS0offset):(318.25 + xStrach1offset))
		)
	    ))
	(pcLayer = 24)
	(pcPurpose = "drawing")
	(pcInst = dbCreateRect(pcCellView
		list(pcLayer pcPurpose)
		list((-0.25:(287.75 + xStrach1offset))
		    ((0.35 + XS0offset):(289.25 + xStrach1offset))
		)
	    ))
	(pcLayer = 24)
	(pcPurpose = "drawing")
	(pcInst = dbCreateRect(pcCellView
		list(pcLayer pcPurpose)
		list((-0.25:(257.9 + xStrach1offset))
		    ((0.35 + XS0offset):(261.4 + xStrach1offset))
		)
	    ))
	(pcLayer = 24)
	(pcPurpose = "drawing")
	(pcInst = dbCreateRect(pcCellView
		list(pcLayer pcPurpose)
		list((-0.25:(177.65 + xStrach1offset))
		    ((0.35 + XS0offset):(261.4 + xStrach1offset))
		)
	    ))
	t
    )
)
