shapeId = schCreateSymbolShape( cvSym "rectangle" "outline" list(X0:Y0 X1:Y1) )
